* 4-bit SAR ADC schematic-level netlist
.option post=2 nomod
.temp 27
.param Lmin=0.18u
.model nch nmos level=1 vto=0.45 kp=220u lambda=0.05
.model pch pmos level=1 vto=-0.45 kp=85u lambda=0.06
VDD VDD 0 1.8
VSS VSS 0 0
VCM VCM 0 0.9
VREFP VREFP 0 1.2
VREFN VREFN 0 0.6
VINP VINP 0 0.9
VINN VINN 0 0.9
VCLK CLK 0 PULSE(0 1.8 0 50p 50p 5n 10n)
VSTART START 0 PULSE(0 1.8 2n 50p 50p 20n 40n)
CLOADP OUTP 0 20f
CLOADN OUTN 0 20f
COUT3 OUT3 0 5f
COUT2 OUT2 0 5f
COUT1 OUT1 0 5f
COUT0 OUT0 0 5f
CDBUS DONE 0 5f

.subckt INV A Y VDD VSS
Mp1 Y A VDD VDD pch W=1.2u L=Lmin
Mn1 Y A VSS VSS nch W=0.6u L=Lmin
.ends INV

.subckt NAND2 A B Y VDD VSS
Mp1 Y A VDD VDD pch W=1.6u L=Lmin
Mp2 Y B VDD VDD pch W=1.6u L=Lmin
Mn1 Y A n1 VSS nch W=1u L=Lmin
Mn2 n1 B VSS VSS nch W=1u L=Lmin
.ends NAND2

.subckt TG IN OUT EN ENB VDD VSS
Mp1 OUT ENB IN VDD pch W=1.6u L=Lmin
Mn1 OUT EN IN VSS nch W=1u L=Lmin
.ends TG

.subckt DLATCH D CLK CLKB Q QB VDD VSS
Xtg1 D n1 CLK CLKB VDD VSS TG
Xinv1 n1 n2 VDD VSS INV
Xtg2 n2 n3 CLKB CLK VDD VSS TG
Xinv2 n3 Q VDD VSS INV
Xinv3 Q QB VDD VSS INV
.ends DLATCH

.subckt DFF D CLK CLKB Q QB VDD VSS
Xl1 D CLK CLKB n1 n1b VDD VSS DLATCH
Xl2 n1 CLK CLKB Q QB VDD VSS DLATCH
.ends DFF

.subckt SA_COMP INP INN CLK OUTP OUTN VDD VSS
Mn1 net1 CLK VSS VSS nch W=6u L=Lmin
Mn2 net2 CLK VSS VSS nch W=6u L=Lmin
Mn3 OUTP INN net1 VSS nch W=4u L=Lmin
Mn4 OUTN INP net2 VSS nch W=4u L=Lmin
Mn5 net1 INP tail VSS nch W=3u L=Lmin
Mn6 net2 INN tail VSS nch W=3u L=Lmin
Mn7 tail CLK VSS VSS nch W=8u L=Lmin
Mp1 OUTP CLK VDD VDD pch W=4u L=Lmin
Mp2 OUTN CLK VDD VDD pch W=4u L=Lmin
Mp3 net1 RST VDD VDD pch W=2u L=Lmin
Mp4 net2 RST VDD VDD pch W=2u L=Lmin
Mp5 RST CLK VDD VDD pch W=2u L=Lmin
.ends SA_COMP

.subckt CDAC_BIT TOP BOT SWP SWN VREFP VREFN VCM VDD VSS
Cmain TOP BOT 4f
Cbot BOT VSS 0.8f
Rswp SWP TOP 0.22
RswN SWN BOT 0.22
Rleak BOT VSS 50Meg
.ends CDAC_BIT

.subckt CDAC4 DACP DACN SWP3 SWN3 SWP2 SWN2 SWP1 SWN1 SWP0 SWN0 VREFP VREFN VCM VDD VSS
Xb3 DACP n3p SWP3 SWN3 VREFP VREFN VCM VDD VSS CDAC_BIT
Xb2 n3p n2p SWP2 SWN2 VREFP VREFN VCM VDD VSS CDAC_BIT
Xb1 n2p n1p SWP1 SWN1 VREFP VREFN VCM VDD VSS CDAC_BIT
Xb0 n1p n0p SWP0 SWN0 VREFP VREFN VCM VDD VSS CDAC_BIT
Xc3 DACN n3n SWP3 SWN3 VREFP VREFN VCM VDD VSS CDAC_BIT
Xc2 n3n n2n SWP2 SWN2 VREFP VREFN VCM VDD VSS CDAC_BIT
Xc1 n2n n1n SWP1 SWN1 VREFP VREFN VCM VDD VSS CDAC_BIT
Xc0 n1n n0n SWP0 SWN0 VREFP VREFN VCM VDD VSS CDAC_BIT
.ends CDAC4

.subckt SAR_CTRL4 CLK CLKB START CMP DONE OUT3 OUT2 OUT1 OUT0 VDD VSS
Xinv0 START nst VDD VSS INV
Xinv1 CLK nclk VDD VSS INV
Xff3 d3 CLK CLKB q3 qb3 VDD VSS DFF
Xff2 d2 CLK CLKB q2 qb2 VDD VSS DFF
Xff1 d1 CLK CLKB q1 qb1 VDD VSS DFF
Xff0 d0 CLK CLKB q0 qb0 VDD VSS DFF
Xg3 q3 CMP d3 VDD VSS NAND2
Xg2 q2 CMP d2 VDD VSS NAND2
Xg1 q1 CMP d1 VDD VSS NAND2
Xg0 q0 CMP d0 VDD VSS NAND2
Xr1 nst q3 out3 VDD VSS NAND2
Xr2 nst q2 out2 VDD VSS NAND2
Xr3 nst q1 out1 VDD VSS NAND2
Xr4 nst q0 out0 VDD VSS NAND2
Xbuf3 out3 OUT3 VDD VSS INV
Xbuf2 out2 OUT2 VDD VSS INV
Xbuf1 out1 OUT1 VDD VSS INV
Xbuf0 out0 OUT0 VDD VSS INV
Xdone1 q3 done1 VDD VSS INV
Xdone2 q2 done2 VDD VSS INV
Xdone3 q1 done3 VDD VSS INV
Xdone4 q0 done4 VDD VSS INV
Xand1 done1 done2 done12 VDD VSS NAND2
Xand2 done3 done4 done34 VDD VSS NAND2
Xand3 done12 done34 DONE VDD VSS NAND2
.ends SAR_CTRL4

XSA SA_INP SA_INN CLK COMP COMPB VDD VSS SA_COMP
XCDAC SA_INP SA_INN SWP3 SWN3 SWP2 SWN2 SWP1 SWN1 SWP0 SWN0 VREFP VREFN VCM VDD VSS CDAC4
XSAR CLK CLKB START COMP DONE OUT3 OUT2 OUT1 OUT0 VDD VSS SAR_CTRL4
RINP VINP SA_INP 0.35
RINN VINN SA_INN 0.35
CCOMP COMP VSS 3f
CCOMPB COMPB VSS 3f
Rswp3 SWP3 0 100Meg
Rswp2 SWP2 0 100Meg
Rswp1 SWP1 0 100Meg
Rswp0 SWP0 0 100Meg
RswN3 SWN3 0 100Meg
RswN2 SWN2 0 100Meg
RswN1 SWN1 0 100Meg
RswN0 SWN0 0 100Meg
.op
.tran 1n 100n
.measure tran vcomp_pp pp v(COMP) from=1u to=2u
.end

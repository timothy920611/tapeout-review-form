* Fully flattened 4-bit SAR ADC post-layout netlist
* Flattened from schematic-level hierarchy; DFF/NAND/INV/TG inlined
.option post=2 nomod
.temp 27
.param Lmin=0.18u
.model nch nmos level=1 vto=0.45 kp=220u lambda=0.05
.model pch pmos level=1 vto=-0.45 kp=85u lambda=0.06

* Supplies and stimuli
VDD VDD 0 1.8
VSS VSS 0 0
VCM VCM 0 0.9
VREFP VREFP 0 1.2
VREFN VREFN 0 0.6
VINP VINP 0 0.9
VINN VINN 0 0.9
VCLK CLK 0 PULSE(0 1.8 0 50p 50p 5n 10n)
VSTART START 0 PULSE(0 1.8 2n 50p 50p 20n 40n)

* Package / routing parasitics
RPKG_VDD VDD VDDP 0.18
RPKG_VSS VSS VSSP 0.16
RPKG_CLK CLK CLK1 0.28
RPKG_START START START1 0.24
RPKG_INP VINP VINP1 0.35
RPKG_INN VINN VINN1 0.35
RPKG_VREFP VREFP VREFP1 0.22
RPKG_VREFN VREFN VREFN1 0.22
CPKG_VDD VDDP VSSP 120f
CPKG_VSS VSSP 0 30f
CPKG_CLK CLK1 VSSP 4f
CPKG_START START1 VSSP 2f
CPKG_INP VINP1 VSSP 10f
CPKG_INN VINN1 VSSP 10f
CPKG_VREFP VREFP1 VSSP 8f
CPKG_VREFN VREFN1 VSSP 8f

* Input routing to comparator
RINP VINP1 SA_INP 0.35
RINN VINN1 SA_INN 0.35
CCOMP COMP VSSP 3f
CCOMPB COMPB VSSP 3f
RCOMP_P COMP COMPx 0.14
RCOMPB_P COMPB COMPBx 0.14
CCOMP_P COMPx VSSP 1.2f
CCOMPB_P COMPBx VSSP 1.2f

* Flattened StrongARM comparator with extracted parasitics
Mn_SA1 net1 CLK1 VSSP VSSP nch W=6u L=0.18u
Mn_SA2 net2 CLK1 VSSP VSSP nch W=6u L=0.18u
Mn_SA3 COMPx VINN net1 VSSP nch W=4u L=0.18u
Mn_SA4 COMPBx VINP net2 VSSP nch W=4u L=0.18u
Mn_SA5 net1 VINP tail VSSP nch W=3u L=0.18u
Mn_SA6 net2 VINN tail VSSP nch W=3u L=0.18u
Mn_SA7 tail CLK1 VSSP VSSP nch W=8u L=0.18u
Mp_SA1 COMPx CLK1 VDDP VDDP pch W=4u L=0.18u
Mp_SA2 COMPBx CLK1 VDDP VDDP pch W=4u L=0.18u
Mp_SA3 net1 RST VDDP VDDP pch W=2u L=0.18u
Mp_SA4 net2 RST VDDP VDDP pch W=2u L=0.18u
Mp_SA5 RST CLK1 VDDP VDDP pch W=2u L=0.18u
R_SA1 COMPx VSSP 2Meg
R_SA2 COMPBx VSSP 2Meg
C_SA1 COMPx VSSP 12f
C_SA2 COMPBx VSSP 12f

* CDAC routing parasitics and capacitors
RCDAC_P0 SA_INP SA_INP1 0.20
CP0 SA_INP1 VSSP 1.0f
RCDAC_P1 SA_INP1 n3p 0.08
RCDAC_P2 n3p n2p 0.06
RCDAC_P3 n2p n1p 0.05
RCDAC_P4 n1p n0p 0.04
CP1 n3p VSSP 0.8f
CP2 n2p VSSP 0.7f
CP3 n1p VSSP 0.6f
CP4 n0p VSSP 0.5f
CMAIN_P3 n3p n2p 4f
CMAIN_P2 n2p n1p 2f
CMAIN_P1 n1p n0p 1f
RLEAK_P3 n3p VSSP 50Meg
RLEAK_P2 n2p VSSP 50Meg
RLEAK_P1 n1p VSSP 50Meg
RLEAK_P0 n0p VSSP 50Meg
RCDAC_N0 SA_INN SA_INN1 0.20
CN0 SA_INN1 VSSP 1.0f
RCDAC_N1 SA_INN1 n3n 0.08
RCDAC_N2 n3n n2n 0.06
RCDAC_N3 n2n n1n 0.05
RCDAC_N4 n1n n0n 0.04
CN1 n3n VSSP 0.8f
CN2 n2n VSSP 0.7f
CN3 n1n VSSP 0.6f
CN4 n0n VSSP 0.5f
CMAIN_N3 n3n n2n 4f
CMAIN_N2 n2n n1n 2f
CMAIN_N1 n1n n0n 1f
RLEAK_N3 n3n VSSP 50Meg
RLEAK_N2 n2n VSSP 50Meg
RLEAK_N1 n1n VSSP 50Meg
RLEAK_N0 n0n VSSP 50Meg
Rcmp_p SA_INP n3p 0.15
Rcmp_n SA_INN n3n 0.15
Ccm_p n0p VSSP 4f
Ccm_n n0n VSSP 4f
Rswp3 SWP3 SWP3x 0.10
Rswp2 SWP2 SWP2x 0.10
Rswp1 SWP1 SWP1x 0.10
Rswp0 SWP0 SWP0x 0.10
RswN3 SWN3 SWN3x 0.10
RswN2 SWN2 SWN2x 0.10
RswN1 SWN1 SWN1x 0.10
RswN0 SWN0 SWN0x 0.10
Cswp3 SWP3x VSSP 0.6f
Cswp2 SWP2x VSSP 0.6f
Cswp1 SWP1x VSSP 0.6f
Cswp0 SWP0x VSSP 0.6f
CswN3 SWN3x VSSP 0.6f
CswN2 SWN2x VSSP 0.6f
CswN1 SWN1x VSSP 0.6f
CswN0 SWN0x VSSP 0.6f

* Flattened SAR control logic: INV / NAND / DFF / TG / latches inlined
* Local clock complement
RCLKINV_IN CLK1 CLK1a 0.10
CCLKINV_IN CLK1a VSSP 0.7f
Mp_CLKINV_P CLKB CLK1a VDDP VDDP pch W=1.2u L=0.18u
Mn_CLKINV_N CLKB CLK1a VSSP VSSP nch W=0.6u L=0.18u
RCLKINV_OUT CLKB CLKBx 0.14
CCLKBOUT CLKBx VSSP 0.9f

* START inverter
RSTART_IN START1 START1a 0.10
CSTART_IN START1a VSSP 0.7f
Mp_START_P nst START1a VDDP VDDP pch W=1.2u L=0.18u
Mn_START_N nst START1a VSSP VSSP nch W=0.6u L=0.18u
RSTART_OUT nst nstx 0.14
CNSTART_OUT nstx VSSP 0.9f

R_D3_A q3 q3_x 0.12
C_D3_A q3_x VSSP 0.6f
R_D3_B COMPx COMPx_x 0.12
C_D3_B COMPx_x VSSP 0.6f
Mp_D3_P1 d3 q3_x VDDP VDDP pch W=1.6u L=0.18u
Mp_D3_P2 d3 COMPx_x VDDP VDDP pch W=1.6u L=0.18u
Mn_D3_N1 d3 q3_x D3_n1 VSSP nch W=1.0u L=0.18u
Mn_D3_N2 D3_n1 COMPx_x VSSP VSSP nch W=1.0u L=0.18u
R_D3_OUT d3 d3_x 0.16
C_D3_OUT d3_x VSSP 1.0f
R_FF3_L1_TG1_EN CLK1 CLK1_x 0.08
R_FF3_L1_TG1_ENB CLKB CLKB_x 0.08
C_FF3_L1_TG1_EN CLK1_x VSSP 0.6f
C_FF3_L1_TG1_ENB CLKB_x VSSP 0.6f
Mp_FF3_L1_TG1_P FF3_L1_n1 CLKB_x d3 VDDP pch W=1.6u L=0.18u
Mn_FF3_L1_TG1_N FF3_L1_n1 CLK1_x d3 VSSP nch W=1.0u L=0.18u
R_FF3_L1_TG1_IO d3 FF3_L1_n1 0.05
C_FF3_L1_TG1_IO FF3_L1_n1 VSSP 0.5f
R_FF3_L1_INV1_IN FF3_L1_n1 FF3_L1_n1_x 0.1
C_FF3_L1_INV1_IN FF3_L1_n1_x VSSP 0.7f
Mp_FF3_L1_INV1_P FF3_L1_n2 FF3_L1_n1_x VDDP VDDP pch W=1.2u L=0.18u
Mn_FF3_L1_INV1_N FF3_L1_n2 FF3_L1_n1_x VSSP VSSP nch W=0.6u L=0.18u
R_FF3_L1_INV1_OUT FF3_L1_n2 FF3_L1_n2_x 0.14
C_FF3_L1_INV1_OUT FF3_L1_n2_x VSSP 0.9f
R_FF3_L1_TG2_EN CLKB CLKB_x 0.08
R_FF3_L1_TG2_ENB CLK1 CLK1_x 0.08
C_FF3_L1_TG2_EN CLKB_x VSSP 0.6f
C_FF3_L1_TG2_ENB CLK1_x VSSP 0.6f
Mp_FF3_L1_TG2_P FF3_L1_n3 CLK1_x FF3_L1_n2 VDDP pch W=1.6u L=0.18u
Mn_FF3_L1_TG2_N FF3_L1_n3 CLKB_x FF3_L1_n2 VSSP nch W=1.0u L=0.18u
R_FF3_L1_TG2_IO FF3_L1_n2 FF3_L1_n3 0.05
C_FF3_L1_TG2_IO FF3_L1_n3 VSSP 0.5f
R_FF3_L1_INV2_IN FF3_L1_n3 FF3_L1_n3_x 0.1
C_FF3_L1_INV2_IN FF3_L1_n3_x VSSP 0.7f
Mp_FF3_L1_INV2_P FF3_m FF3_L1_n3_x VDDP VDDP pch W=1.2u L=0.18u
Mn_FF3_L1_INV2_N FF3_m FF3_L1_n3_x VSSP VSSP nch W=0.6u L=0.18u
R_FF3_L1_INV2_OUT FF3_m FF3_m_x 0.14
C_FF3_L1_INV2_OUT FF3_m_x VSSP 0.9f
R_FF3_L1_INV3_IN FF3_m FF3_m_x 0.1
C_FF3_L1_INV3_IN FF3_m_x VSSP 0.7f
Mp_FF3_L1_INV3_P FF3_mb FF3_m_x VDDP VDDP pch W=1.2u L=0.18u
Mn_FF3_L1_INV3_N FF3_mb FF3_m_x VSSP VSSP nch W=0.6u L=0.18u
R_FF3_L1_INV3_OUT FF3_mb FF3_mb_x 0.14
C_FF3_L1_INV3_OUT FF3_mb_x VSSP 0.9f
R_FF3_L1_KEEP FF3_m FF3_L1_keep 10Meg
C_FF3_L1_KEEP FF3_L1_keep VSSP 0.2f
R_FF3_L2_TG1_EN CLK1 CLK1_x 0.08
R_FF3_L2_TG1_ENB CLKB CLKB_x 0.08
C_FF3_L2_TG1_EN CLK1_x VSSP 0.6f
C_FF3_L2_TG1_ENB CLKB_x VSSP 0.6f
Mp_FF3_L2_TG1_P FF3_L2_n1 CLKB_x FF3_m VDDP pch W=1.6u L=0.18u
Mn_FF3_L2_TG1_N FF3_L2_n1 CLK1_x FF3_m VSSP nch W=1.0u L=0.18u
R_FF3_L2_TG1_IO FF3_m FF3_L2_n1 0.05
C_FF3_L2_TG1_IO FF3_L2_n1 VSSP 0.5f
R_FF3_L2_INV1_IN FF3_L2_n1 FF3_L2_n1_x 0.1
C_FF3_L2_INV1_IN FF3_L2_n1_x VSSP 0.7f
Mp_FF3_L2_INV1_P FF3_L2_n2 FF3_L2_n1_x VDDP VDDP pch W=1.2u L=0.18u
Mn_FF3_L2_INV1_N FF3_L2_n2 FF3_L2_n1_x VSSP VSSP nch W=0.6u L=0.18u
R_FF3_L2_INV1_OUT FF3_L2_n2 FF3_L2_n2_x 0.14
C_FF3_L2_INV1_OUT FF3_L2_n2_x VSSP 0.9f
R_FF3_L2_TG2_EN CLKB CLKB_x 0.08
R_FF3_L2_TG2_ENB CLK1 CLK1_x 0.08
C_FF3_L2_TG2_EN CLKB_x VSSP 0.6f
C_FF3_L2_TG2_ENB CLK1_x VSSP 0.6f
Mp_FF3_L2_TG2_P FF3_L2_n3 CLK1_x FF3_L2_n2 VDDP pch W=1.6u L=0.18u
Mn_FF3_L2_TG2_N FF3_L2_n3 CLKB_x FF3_L2_n2 VSSP nch W=1.0u L=0.18u
R_FF3_L2_TG2_IO FF3_L2_n2 FF3_L2_n3 0.05
C_FF3_L2_TG2_IO FF3_L2_n3 VSSP 0.5f
R_FF3_L2_INV2_IN FF3_L2_n3 FF3_L2_n3_x 0.1
C_FF3_L2_INV2_IN FF3_L2_n3_x VSSP 0.7f
Mp_FF3_L2_INV2_P q3 FF3_L2_n3_x VDDP VDDP pch W=1.2u L=0.18u
Mn_FF3_L2_INV2_N q3 FF3_L2_n3_x VSSP VSSP nch W=0.6u L=0.18u
R_FF3_L2_INV2_OUT q3 q3_x 0.14
C_FF3_L2_INV2_OUT q3_x VSSP 0.9f
R_FF3_L2_INV3_IN q3 q3_x 0.1
C_FF3_L2_INV3_IN q3_x VSSP 0.7f
Mp_FF3_L2_INV3_P qb3 q3_x VDDP VDDP pch W=1.2u L=0.18u
Mn_FF3_L2_INV3_N qb3 q3_x VSSP VSSP nch W=0.6u L=0.18u
R_FF3_L2_INV3_OUT qb3 qb3_x 0.14
C_FF3_L2_INV3_OUT qb3_x VSSP 0.9f
R_FF3_L2_KEEP q3 FF3_L2_keep 10Meg
C_FF3_L2_KEEP FF3_L2_keep VSSP 0.2f
R_FF3_CLK CLK1 FF3_clkx 0.09
C_FF3_CLK FF3_clkx VSSP 0.9f
R_OUT3_A nst nst_x 0.12
C_OUT3_A nst_x VSSP 0.6f
R_OUT3_B q3 q3_x 0.12
C_OUT3_B q3_x VSSP 0.6f
Mp_OUT3_P1 out3 nst_x VDDP VDDP pch W=1.6u L=0.18u
Mp_OUT3_P2 out3 q3_x VDDP VDDP pch W=1.6u L=0.18u
Mn_OUT3_N1 out3 nst_x OUT3_n1 VSSP nch W=1.0u L=0.18u
Mn_OUT3_N2 OUT3_n1 q3_x VSSP VSSP nch W=1.0u L=0.18u
R_OUT3_OUT out3 out3_x 0.16
C_OUT3_OUT out3_x VSSP 1.0f
R_OUTBUF3A_IN out3 out3_x 0.1
C_OUTBUF3A_IN out3_x VSSP 0.7f
Mp_OUTBUF3A_P OUT3i out3_x VDDP VDDP pch W=1.2u L=0.18u
Mn_OUTBUF3A_N OUT3i out3_x VSSP VSSP nch W=0.6u L=0.18u
R_OUTBUF3A_OUT OUT3i OUT3i_x 0.14
C_OUTBUF3A_OUT OUT3i_x VSSP 0.9f
R_OUTBUF3B_IN OUT3i OUT3i_x 0.1
C_OUTBUF3B_IN OUT3i_x VSSP 0.7f
Mp_OUTBUF3B_P OUT3 OUT3i_x VDDP VDDP pch W=1.2u L=0.18u
Mn_OUTBUF3B_N OUT3 OUT3i_x VSSP VSSP nch W=0.6u L=0.18u
R_OUTBUF3B_OUT OUT3 OUT3_x 0.14
C_OUTBUF3B_OUT OUT3_x VSSP 0.9f
R_OUT3_TR OUT3i OUT3x 0.13
C_OUT3_TR OUT3x VSSP 0.8f
R_D2_A q2 q2_x 0.12
C_D2_A q2_x VSSP 0.6f
R_D2_B COMPx COMPx_x 0.12
C_D2_B COMPx_x VSSP 0.6f
Mp_D2_P1 d2 q2_x VDDP VDDP pch W=1.6u L=0.18u
Mp_D2_P2 d2 COMPx_x VDDP VDDP pch W=1.6u L=0.18u
Mn_D2_N1 d2 q2_x D2_n1 VSSP nch W=1.0u L=0.18u
Mn_D2_N2 D2_n1 COMPx_x VSSP VSSP nch W=1.0u L=0.18u
R_D2_OUT d2 d2_x 0.16
C_D2_OUT d2_x VSSP 1.0f
R_FF2_L1_TG1_EN CLK1 CLK1_x 0.08
R_FF2_L1_TG1_ENB CLKB CLKB_x 0.08
C_FF2_L1_TG1_EN CLK1_x VSSP 0.6f
C_FF2_L1_TG1_ENB CLKB_x VSSP 0.6f
Mp_FF2_L1_TG1_P FF2_L1_n1 CLKB_x d2 VDDP pch W=1.6u L=0.18u
Mn_FF2_L1_TG1_N FF2_L1_n1 CLK1_x d2 VSSP nch W=1.0u L=0.18u
R_FF2_L1_TG1_IO d2 FF2_L1_n1 0.05
C_FF2_L1_TG1_IO FF2_L1_n1 VSSP 0.5f
R_FF2_L1_INV1_IN FF2_L1_n1 FF2_L1_n1_x 0.1
C_FF2_L1_INV1_IN FF2_L1_n1_x VSSP 0.7f
Mp_FF2_L1_INV1_P FF2_L1_n2 FF2_L1_n1_x VDDP VDDP pch W=1.2u L=0.18u
Mn_FF2_L1_INV1_N FF2_L1_n2 FF2_L1_n1_x VSSP VSSP nch W=0.6u L=0.18u
R_FF2_L1_INV1_OUT FF2_L1_n2 FF2_L1_n2_x 0.14
C_FF2_L1_INV1_OUT FF2_L1_n2_x VSSP 0.9f
R_FF2_L1_TG2_EN CLKB CLKB_x 0.08
R_FF2_L1_TG2_ENB CLK1 CLK1_x 0.08
C_FF2_L1_TG2_EN CLKB_x VSSP 0.6f
C_FF2_L1_TG2_ENB CLK1_x VSSP 0.6f
Mp_FF2_L1_TG2_P FF2_L1_n3 CLK1_x FF2_L1_n2 VDDP pch W=1.6u L=0.18u
Mn_FF2_L1_TG2_N FF2_L1_n3 CLKB_x FF2_L1_n2 VSSP nch W=1.0u L=0.18u
R_FF2_L1_TG2_IO FF2_L1_n2 FF2_L1_n3 0.05
C_FF2_L1_TG2_IO FF2_L1_n3 VSSP 0.5f
R_FF2_L1_INV2_IN FF2_L1_n3 FF2_L1_n3_x 0.1
C_FF2_L1_INV2_IN FF2_L1_n3_x VSSP 0.7f
Mp_FF2_L1_INV2_P FF2_m FF2_L1_n3_x VDDP VDDP pch W=1.2u L=0.18u
Mn_FF2_L1_INV2_N FF2_m FF2_L1_n3_x VSSP VSSP nch W=0.6u L=0.18u
R_FF2_L1_INV2_OUT FF2_m FF2_m_x 0.14
C_FF2_L1_INV2_OUT FF2_m_x VSSP 0.9f
R_FF2_L1_INV3_IN FF2_m FF2_m_x 0.1
C_FF2_L1_INV3_IN FF2_m_x VSSP 0.7f
Mp_FF2_L1_INV3_P FF2_mb FF2_m_x VDDP VDDP pch W=1.2u L=0.18u
Mn_FF2_L1_INV3_N FF2_mb FF2_m_x VSSP VSSP nch W=0.6u L=0.18u
R_FF2_L1_INV3_OUT FF2_mb FF2_mb_x 0.14
C_FF2_L1_INV3_OUT FF2_mb_x VSSP 0.9f
R_FF2_L1_KEEP FF2_m FF2_L1_keep 10Meg
C_FF2_L1_KEEP FF2_L1_keep VSSP 0.2f
R_FF2_L2_TG1_EN CLK1 CLK1_x 0.08
R_FF2_L2_TG1_ENB CLKB CLKB_x 0.08
C_FF2_L2_TG1_EN CLK1_x VSSP 0.6f
C_FF2_L2_TG1_ENB CLKB_x VSSP 0.6f
Mp_FF2_L2_TG1_P FF2_L2_n1 CLKB_x FF2_m VDDP pch W=1.6u L=0.18u
Mn_FF2_L2_TG1_N FF2_L2_n1 CLK1_x FF2_m VSSP nch W=1.0u L=0.18u
R_FF2_L2_TG1_IO FF2_m FF2_L2_n1 0.05
C_FF2_L2_TG1_IO FF2_L2_n1 VSSP 0.5f
R_FF2_L2_INV1_IN FF2_L2_n1 FF2_L2_n1_x 0.1
C_FF2_L2_INV1_IN FF2_L2_n1_x VSSP 0.7f
Mp_FF2_L2_INV1_P FF2_L2_n2 FF2_L2_n1_x VDDP VDDP pch W=1.2u L=0.18u
Mn_FF2_L2_INV1_N FF2_L2_n2 FF2_L2_n1_x VSSP VSSP nch W=0.6u L=0.18u
R_FF2_L2_INV1_OUT FF2_L2_n2 FF2_L2_n2_x 0.14
C_FF2_L2_INV1_OUT FF2_L2_n2_x VSSP 0.9f
R_FF2_L2_TG2_EN CLKB CLKB_x 0.08
R_FF2_L2_TG2_ENB CLK1 CLK1_x 0.08
C_FF2_L2_TG2_EN CLKB_x VSSP 0.6f
C_FF2_L2_TG2_ENB CLK1_x VSSP 0.6f
Mp_FF2_L2_TG2_P FF2_L2_n3 CLK1_x FF2_L2_n2 VDDP pch W=1.6u L=0.18u
Mn_FF2_L2_TG2_N FF2_L2_n3 CLKB_x FF2_L2_n2 VSSP nch W=1.0u L=0.18u
R_FF2_L2_TG2_IO FF2_L2_n2 FF2_L2_n3 0.05
C_FF2_L2_TG2_IO FF2_L2_n3 VSSP 0.5f
R_FF2_L2_INV2_IN FF2_L2_n3 FF2_L2_n3_x 0.1
C_FF2_L2_INV2_IN FF2_L2_n3_x VSSP 0.7f
Mp_FF2_L2_INV2_P q2 FF2_L2_n3_x VDDP VDDP pch W=1.2u L=0.18u
Mn_FF2_L2_INV2_N q2 FF2_L2_n3_x VSSP VSSP nch W=0.6u L=0.18u
R_FF2_L2_INV2_OUT q2 q2_x 0.14
C_FF2_L2_INV2_OUT q2_x VSSP 0.9f
R_FF2_L2_INV3_IN q2 q2_x 0.1
C_FF2_L2_INV3_IN q2_x VSSP 0.7f
Mp_FF2_L2_INV3_P qb2 q2_x VDDP VDDP pch W=1.2u L=0.18u
Mn_FF2_L2_INV3_N qb2 q2_x VSSP VSSP nch W=0.6u L=0.18u
R_FF2_L2_INV3_OUT qb2 qb2_x 0.14
C_FF2_L2_INV3_OUT qb2_x VSSP 0.9f
R_FF2_L2_KEEP q2 FF2_L2_keep 10Meg
C_FF2_L2_KEEP FF2_L2_keep VSSP 0.2f
R_FF2_CLK CLK1 FF2_clkx 0.09
C_FF2_CLK FF2_clkx VSSP 0.9f
R_OUT2_A nst nst_x 0.12
C_OUT2_A nst_x VSSP 0.6f
R_OUT2_B q2 q2_x 0.12
C_OUT2_B q2_x VSSP 0.6f
Mp_OUT2_P1 out2 nst_x VDDP VDDP pch W=1.6u L=0.18u
Mp_OUT2_P2 out2 q2_x VDDP VDDP pch W=1.6u L=0.18u
Mn_OUT2_N1 out2 nst_x OUT2_n1 VSSP nch W=1.0u L=0.18u
Mn_OUT2_N2 OUT2_n1 q2_x VSSP VSSP nch W=1.0u L=0.18u
R_OUT2_OUT out2 out2_x 0.16
C_OUT2_OUT out2_x VSSP 1.0f
R_OUTBUF2A_IN out2 out2_x 0.1
C_OUTBUF2A_IN out2_x VSSP 0.7f
Mp_OUTBUF2A_P OUT2i out2_x VDDP VDDP pch W=1.2u L=0.18u
Mn_OUTBUF2A_N OUT2i out2_x VSSP VSSP nch W=0.6u L=0.18u
R_OUTBUF2A_OUT OUT2i OUT2i_x 0.14
C_OUTBUF2A_OUT OUT2i_x VSSP 0.9f
R_OUTBUF2B_IN OUT2i OUT2i_x 0.1
C_OUTBUF2B_IN OUT2i_x VSSP 0.7f
Mp_OUTBUF2B_P OUT2 OUT2i_x VDDP VDDP pch W=1.2u L=0.18u
Mn_OUTBUF2B_N OUT2 OUT2i_x VSSP VSSP nch W=0.6u L=0.18u
R_OUTBUF2B_OUT OUT2 OUT2_x 0.14
C_OUTBUF2B_OUT OUT2_x VSSP 0.9f
R_OUT2_TR OUT2i OUT2x 0.13
C_OUT2_TR OUT2x VSSP 0.8f
R_D1_A q1 q1_x 0.12
C_D1_A q1_x VSSP 0.6f
R_D1_B COMPx COMPx_x 0.12
C_D1_B COMPx_x VSSP 0.6f
Mp_D1_P1 d1 q1_x VDDP VDDP pch W=1.6u L=0.18u
Mp_D1_P2 d1 COMPx_x VDDP VDDP pch W=1.6u L=0.18u
Mn_D1_N1 d1 q1_x D1_n1 VSSP nch W=1.0u L=0.18u
Mn_D1_N2 D1_n1 COMPx_x VSSP VSSP nch W=1.0u L=0.18u
R_D1_OUT d1 d1_x 0.16
C_D1_OUT d1_x VSSP 1.0f
R_FF1_L1_TG1_EN CLK1 CLK1_x 0.08
R_FF1_L1_TG1_ENB CLKB CLKB_x 0.08
C_FF1_L1_TG1_EN CLK1_x VSSP 0.6f
C_FF1_L1_TG1_ENB CLKB_x VSSP 0.6f
Mp_FF1_L1_TG1_P FF1_L1_n1 CLKB_x d1 VDDP pch W=1.6u L=0.18u
Mn_FF1_L1_TG1_N FF1_L1_n1 CLK1_x d1 VSSP nch W=1.0u L=0.18u
R_FF1_L1_TG1_IO d1 FF1_L1_n1 0.05
C_FF1_L1_TG1_IO FF1_L1_n1 VSSP 0.5f
R_FF1_L1_INV1_IN FF1_L1_n1 FF1_L1_n1_x 0.1
C_FF1_L1_INV1_IN FF1_L1_n1_x VSSP 0.7f
Mp_FF1_L1_INV1_P FF1_L1_n2 FF1_L1_n1_x VDDP VDDP pch W=1.2u L=0.18u
Mn_FF1_L1_INV1_N FF1_L1_n2 FF1_L1_n1_x VSSP VSSP nch W=0.6u L=0.18u
R_FF1_L1_INV1_OUT FF1_L1_n2 FF1_L1_n2_x 0.14
C_FF1_L1_INV1_OUT FF1_L1_n2_x VSSP 0.9f
R_FF1_L1_TG2_EN CLKB CLKB_x 0.08
R_FF1_L1_TG2_ENB CLK1 CLK1_x 0.08
C_FF1_L1_TG2_EN CLKB_x VSSP 0.6f
C_FF1_L1_TG2_ENB CLK1_x VSSP 0.6f
Mp_FF1_L1_TG2_P FF1_L1_n3 CLK1_x FF1_L1_n2 VDDP pch W=1.6u L=0.18u
Mn_FF1_L1_TG2_N FF1_L1_n3 CLKB_x FF1_L1_n2 VSSP nch W=1.0u L=0.18u
R_FF1_L1_TG2_IO FF1_L1_n2 FF1_L1_n3 0.05
C_FF1_L1_TG2_IO FF1_L1_n3 VSSP 0.5f
R_FF1_L1_INV2_IN FF1_L1_n3 FF1_L1_n3_x 0.1
C_FF1_L1_INV2_IN FF1_L1_n3_x VSSP 0.7f
Mp_FF1_L1_INV2_P FF1_m FF1_L1_n3_x VDDP VDDP pch W=1.2u L=0.18u
Mn_FF1_L1_INV2_N FF1_m FF1_L1_n3_x VSSP VSSP nch W=0.6u L=0.18u
R_FF1_L1_INV2_OUT FF1_m FF1_m_x 0.14
C_FF1_L1_INV2_OUT FF1_m_x VSSP 0.9f
R_FF1_L1_INV3_IN FF1_m FF1_m_x 0.1
C_FF1_L1_INV3_IN FF1_m_x VSSP 0.7f
Mp_FF1_L1_INV3_P FF1_mb FF1_m_x VDDP VDDP pch W=1.2u L=0.18u
Mn_FF1_L1_INV3_N FF1_mb FF1_m_x VSSP VSSP nch W=0.6u L=0.18u
R_FF1_L1_INV3_OUT FF1_mb FF1_mb_x 0.14
C_FF1_L1_INV3_OUT FF1_mb_x VSSP 0.9f
R_FF1_L1_KEEP FF1_m FF1_L1_keep 10Meg
C_FF1_L1_KEEP FF1_L1_keep VSSP 0.2f
R_FF1_L2_TG1_EN CLK1 CLK1_x 0.08
R_FF1_L2_TG1_ENB CLKB CLKB_x 0.08
C_FF1_L2_TG1_EN CLK1_x VSSP 0.6f
C_FF1_L2_TG1_ENB CLKB_x VSSP 0.6f
Mp_FF1_L2_TG1_P FF1_L2_n1 CLKB_x FF1_m VDDP pch W=1.6u L=0.18u
Mn_FF1_L2_TG1_N FF1_L2_n1 CLK1_x FF1_m VSSP nch W=1.0u L=0.18u
R_FF1_L2_TG1_IO FF1_m FF1_L2_n1 0.05
C_FF1_L2_TG1_IO FF1_L2_n1 VSSP 0.5f
R_FF1_L2_INV1_IN FF1_L2_n1 FF1_L2_n1_x 0.1
C_FF1_L2_INV1_IN FF1_L2_n1_x VSSP 0.7f
Mp_FF1_L2_INV1_P FF1_L2_n2 FF1_L2_n1_x VDDP VDDP pch W=1.2u L=0.18u
Mn_FF1_L2_INV1_N FF1_L2_n2 FF1_L2_n1_x VSSP VSSP nch W=0.6u L=0.18u
R_FF1_L2_INV1_OUT FF1_L2_n2 FF1_L2_n2_x 0.14
C_FF1_L2_INV1_OUT FF1_L2_n2_x VSSP 0.9f
R_FF1_L2_TG2_EN CLKB CLKB_x 0.08
R_FF1_L2_TG2_ENB CLK1 CLK1_x 0.08
C_FF1_L2_TG2_EN CLKB_x VSSP 0.6f
C_FF1_L2_TG2_ENB CLK1_x VSSP 0.6f
Mp_FF1_L2_TG2_P FF1_L2_n3 CLK1_x FF1_L2_n2 VDDP pch W=1.6u L=0.18u
Mn_FF1_L2_TG2_N FF1_L2_n3 CLKB_x FF1_L2_n2 VSSP nch W=1.0u L=0.18u
R_FF1_L2_TG2_IO FF1_L2_n2 FF1_L2_n3 0.05
C_FF1_L2_TG2_IO FF1_L2_n3 VSSP 0.5f
R_FF1_L2_INV2_IN FF1_L2_n3 FF1_L2_n3_x 0.1
C_FF1_L2_INV2_IN FF1_L2_n3_x VSSP 0.7f
Mp_FF1_L2_INV2_P q1 FF1_L2_n3_x VDDP VDDP pch W=1.2u L=0.18u
Mn_FF1_L2_INV2_N q1 FF1_L2_n3_x VSSP VSSP nch W=0.6u L=0.18u
R_FF1_L2_INV2_OUT q1 q1_x 0.14
C_FF1_L2_INV2_OUT q1_x VSSP 0.9f
R_FF1_L2_INV3_IN q1 q1_x 0.1
C_FF1_L2_INV3_IN q1_x VSSP 0.7f
Mp_FF1_L2_INV3_P qb1 q1_x VDDP VDDP pch W=1.2u L=0.18u
Mn_FF1_L2_INV3_N qb1 q1_x VSSP VSSP nch W=0.6u L=0.18u
R_FF1_L2_INV3_OUT qb1 qb1_x 0.14
C_FF1_L2_INV3_OUT qb1_x VSSP 0.9f
R_FF1_L2_KEEP q1 FF1_L2_keep 10Meg
C_FF1_L2_KEEP FF1_L2_keep VSSP 0.2f
R_FF1_CLK CLK1 FF1_clkx 0.09
C_FF1_CLK FF1_clkx VSSP 0.9f
R_OUT1_A nst nst_x 0.12
C_OUT1_A nst_x VSSP 0.6f
R_OUT1_B q1 q1_x 0.12
C_OUT1_B q1_x VSSP 0.6f
Mp_OUT1_P1 out1 nst_x VDDP VDDP pch W=1.6u L=0.18u
Mp_OUT1_P2 out1 q1_x VDDP VDDP pch W=1.6u L=0.18u
Mn_OUT1_N1 out1 nst_x OUT1_n1 VSSP nch W=1.0u L=0.18u
Mn_OUT1_N2 OUT1_n1 q1_x VSSP VSSP nch W=1.0u L=0.18u
R_OUT1_OUT out1 out1_x 0.16
C_OUT1_OUT out1_x VSSP 1.0f
R_OUTBUF1A_IN out1 out1_x 0.1
C_OUTBUF1A_IN out1_x VSSP 0.7f
Mp_OUTBUF1A_P OUT1i out1_x VDDP VDDP pch W=1.2u L=0.18u
Mn_OUTBUF1A_N OUT1i out1_x VSSP VSSP nch W=0.6u L=0.18u
R_OUTBUF1A_OUT OUT1i OUT1i_x 0.14
C_OUTBUF1A_OUT OUT1i_x VSSP 0.9f
R_OUTBUF1B_IN OUT1i OUT1i_x 0.1
C_OUTBUF1B_IN OUT1i_x VSSP 0.7f
Mp_OUTBUF1B_P OUT1 OUT1i_x VDDP VDDP pch W=1.2u L=0.18u
Mn_OUTBUF1B_N OUT1 OUT1i_x VSSP VSSP nch W=0.6u L=0.18u
R_OUTBUF1B_OUT OUT1 OUT1_x 0.14
C_OUTBUF1B_OUT OUT1_x VSSP 0.9f
R_OUT1_TR OUT1i OUT1x 0.13
C_OUT1_TR OUT1x VSSP 0.8f
R_D0_A q0 q0_x 0.12
C_D0_A q0_x VSSP 0.6f
R_D0_B COMPx COMPx_x 0.12
C_D0_B COMPx_x VSSP 0.6f
Mp_D0_P1 d0 q0_x VDDP VDDP pch W=1.6u L=0.18u
Mp_D0_P2 d0 COMPx_x VDDP VDDP pch W=1.6u L=0.18u
Mn_D0_N1 d0 q0_x D0_n1 VSSP nch W=1.0u L=0.18u
Mn_D0_N2 D0_n1 COMPx_x VSSP VSSP nch W=1.0u L=0.18u
R_D0_OUT d0 d0_x 0.16
C_D0_OUT d0_x VSSP 1.0f
R_FF0_L1_TG1_EN CLK1 CLK1_x 0.08
R_FF0_L1_TG1_ENB CLKB CLKB_x 0.08
C_FF0_L1_TG1_EN CLK1_x VSSP 0.6f
C_FF0_L1_TG1_ENB CLKB_x VSSP 0.6f
Mp_FF0_L1_TG1_P FF0_L1_n1 CLKB_x d0 VDDP pch W=1.6u L=0.18u
Mn_FF0_L1_TG1_N FF0_L1_n1 CLK1_x d0 VSSP nch W=1.0u L=0.18u
R_FF0_L1_TG1_IO d0 FF0_L1_n1 0.05
C_FF0_L1_TG1_IO FF0_L1_n1 VSSP 0.5f
R_FF0_L1_INV1_IN FF0_L1_n1 FF0_L1_n1_x 0.1
C_FF0_L1_INV1_IN FF0_L1_n1_x VSSP 0.7f
Mp_FF0_L1_INV1_P FF0_L1_n2 FF0_L1_n1_x VDDP VDDP pch W=1.2u L=0.18u
Mn_FF0_L1_INV1_N FF0_L1_n2 FF0_L1_n1_x VSSP VSSP nch W=0.6u L=0.18u
R_FF0_L1_INV1_OUT FF0_L1_n2 FF0_L1_n2_x 0.14
C_FF0_L1_INV1_OUT FF0_L1_n2_x VSSP 0.9f
R_FF0_L1_TG2_EN CLKB CLKB_x 0.08
R_FF0_L1_TG2_ENB CLK1 CLK1_x 0.08
C_FF0_L1_TG2_EN CLKB_x VSSP 0.6f
C_FF0_L1_TG2_ENB CLK1_x VSSP 0.6f
Mp_FF0_L1_TG2_P FF0_L1_n3 CLK1_x FF0_L1_n2 VDDP pch W=1.6u L=0.18u
Mn_FF0_L1_TG2_N FF0_L1_n3 CLKB_x FF0_L1_n2 VSSP nch W=1.0u L=0.18u
R_FF0_L1_TG2_IO FF0_L1_n2 FF0_L1_n3 0.05
C_FF0_L1_TG2_IO FF0_L1_n3 VSSP 0.5f
R_FF0_L1_INV2_IN FF0_L1_n3 FF0_L1_n3_x 0.1
C_FF0_L1_INV2_IN FF0_L1_n3_x VSSP 0.7f
Mp_FF0_L1_INV2_P FF0_m FF0_L1_n3_x VDDP VDDP pch W=1.2u L=0.18u
Mn_FF0_L1_INV2_N FF0_m FF0_L1_n3_x VSSP VSSP nch W=0.6u L=0.18u
R_FF0_L1_INV2_OUT FF0_m FF0_m_x 0.14
C_FF0_L1_INV2_OUT FF0_m_x VSSP 0.9f
R_FF0_L1_INV3_IN FF0_m FF0_m_x 0.1
C_FF0_L1_INV3_IN FF0_m_x VSSP 0.7f
Mp_FF0_L1_INV3_P FF0_mb FF0_m_x VDDP VDDP pch W=1.2u L=0.18u
Mn_FF0_L1_INV3_N FF0_mb FF0_m_x VSSP VSSP nch W=0.6u L=0.18u
R_FF0_L1_INV3_OUT FF0_mb FF0_mb_x 0.14
C_FF0_L1_INV3_OUT FF0_mb_x VSSP 0.9f
R_FF0_L1_KEEP FF0_m FF0_L1_keep 10Meg
C_FF0_L1_KEEP FF0_L1_keep VSSP 0.2f
R_FF0_L2_TG1_EN CLK1 CLK1_x 0.08
R_FF0_L2_TG1_ENB CLKB CLKB_x 0.08
C_FF0_L2_TG1_EN CLK1_x VSSP 0.6f
C_FF0_L2_TG1_ENB CLKB_x VSSP 0.6f
Mp_FF0_L2_TG1_P FF0_L2_n1 CLKB_x FF0_m VDDP pch W=1.6u L=0.18u
Mn_FF0_L2_TG1_N FF0_L2_n1 CLK1_x FF0_m VSSP nch W=1.0u L=0.18u
R_FF0_L2_TG1_IO FF0_m FF0_L2_n1 0.05
C_FF0_L2_TG1_IO FF0_L2_n1 VSSP 0.5f
R_FF0_L2_INV1_IN FF0_L2_n1 FF0_L2_n1_x 0.1
C_FF0_L2_INV1_IN FF0_L2_n1_x VSSP 0.7f
Mp_FF0_L2_INV1_P FF0_L2_n2 FF0_L2_n1_x VDDP VDDP pch W=1.2u L=0.18u
Mn_FF0_L2_INV1_N FF0_L2_n2 FF0_L2_n1_x VSSP VSSP nch W=0.6u L=0.18u
R_FF0_L2_INV1_OUT FF0_L2_n2 FF0_L2_n2_x 0.14
C_FF0_L2_INV1_OUT FF0_L2_n2_x VSSP 0.9f
R_FF0_L2_TG2_EN CLKB CLKB_x 0.08
R_FF0_L2_TG2_ENB CLK1 CLK1_x 0.08
C_FF0_L2_TG2_EN CLKB_x VSSP 0.6f
C_FF0_L2_TG2_ENB CLK1_x VSSP 0.6f
Mp_FF0_L2_TG2_P FF0_L2_n3 CLK1_x FF0_L2_n2 VDDP pch W=1.6u L=0.18u
Mn_FF0_L2_TG2_N FF0_L2_n3 CLKB_x FF0_L2_n2 VSSP nch W=1.0u L=0.18u
R_FF0_L2_TG2_IO FF0_L2_n2 FF0_L2_n3 0.05
C_FF0_L2_TG2_IO FF0_L2_n3 VSSP 0.5f
R_FF0_L2_INV2_IN FF0_L2_n3 FF0_L2_n3_x 0.1
C_FF0_L2_INV2_IN FF0_L2_n3_x VSSP 0.7f
Mp_FF0_L2_INV2_P q0 FF0_L2_n3_x VDDP VDDP pch W=1.2u L=0.18u
Mn_FF0_L2_INV2_N q0 FF0_L2_n3_x VSSP VSSP nch W=0.6u L=0.18u
R_FF0_L2_INV2_OUT q0 q0_x 0.14
C_FF0_L2_INV2_OUT q0_x VSSP 0.9f
R_FF0_L2_INV3_IN q0 q0_x 0.1
C_FF0_L2_INV3_IN q0_x VSSP 0.7f
Mp_FF0_L2_INV3_P qb0 q0_x VDDP VDDP pch W=1.2u L=0.18u
Mn_FF0_L2_INV3_N qb0 q0_x VSSP VSSP nch W=0.6u L=0.18u
R_FF0_L2_INV3_OUT qb0 qb0_x 0.14
C_FF0_L2_INV3_OUT qb0_x VSSP 0.9f
R_FF0_L2_KEEP q0 FF0_L2_keep 10Meg
C_FF0_L2_KEEP FF0_L2_keep VSSP 0.2f
R_FF0_CLK CLK1 FF0_clkx 0.09
C_FF0_CLK FF0_clkx VSSP 0.9f
R_OUT0_A nst nst_x 0.12
C_OUT0_A nst_x VSSP 0.6f
R_OUT0_B q0 q0_x 0.12
C_OUT0_B q0_x VSSP 0.6f
Mp_OUT0_P1 out0 nst_x VDDP VDDP pch W=1.6u L=0.18u
Mp_OUT0_P2 out0 q0_x VDDP VDDP pch W=1.6u L=0.18u
Mn_OUT0_N1 out0 nst_x OUT0_n1 VSSP nch W=1.0u L=0.18u
Mn_OUT0_N2 OUT0_n1 q0_x VSSP VSSP nch W=1.0u L=0.18u
R_OUT0_OUT out0 out0_x 0.16
C_OUT0_OUT out0_x VSSP 1.0f
R_OUTBUF0A_IN out0 out0_x 0.1
C_OUTBUF0A_IN out0_x VSSP 0.7f
Mp_OUTBUF0A_P OUT0i out0_x VDDP VDDP pch W=1.2u L=0.18u
Mn_OUTBUF0A_N OUT0i out0_x VSSP VSSP nch W=0.6u L=0.18u
R_OUTBUF0A_OUT OUT0i OUT0i_x 0.14
C_OUTBUF0A_OUT OUT0i_x VSSP 0.9f
R_OUTBUF0B_IN OUT0i OUT0i_x 0.1
C_OUTBUF0B_IN OUT0i_x VSSP 0.7f
Mp_OUTBUF0B_P OUT0 OUT0i_x VDDP VDDP pch W=1.2u L=0.18u
Mn_OUTBUF0B_N OUT0 OUT0i_x VSSP VSSP nch W=0.6u L=0.18u
R_OUTBUF0B_OUT OUT0 OUT0_x 0.14
C_OUTBUF0B_OUT OUT0_x VSSP 0.9f
R_OUT0_TR OUT0i OUT0x 0.13
C_OUT0_TR OUT0x VSSP 0.8f
R_DONE1_IN q3 q3_x 0.1
C_DONE1_IN q3_x VSSP 0.7f
Mp_DONE1_P done1 q3_x VDDP VDDP pch W=1.2u L=0.18u
Mn_DONE1_N done1 q3_x VSSP VSSP nch W=0.6u L=0.18u
R_DONE1_OUT done1 done1_x 0.14
C_DONE1_OUT done1_x VSSP 0.9f
R_DONE2_IN q2 q2_x 0.1
C_DONE2_IN q2_x VSSP 0.7f
Mp_DONE2_P done2 q2_x VDDP VDDP pch W=1.2u L=0.18u
Mn_DONE2_N done2 q2_x VSSP VSSP nch W=0.6u L=0.18u
R_DONE2_OUT done2 done2_x 0.14
C_DONE2_OUT done2_x VSSP 0.9f
R_DONE3_IN q1 q1_x 0.1
C_DONE3_IN q1_x VSSP 0.7f
Mp_DONE3_P done3 q1_x VDDP VDDP pch W=1.2u L=0.18u
Mn_DONE3_N done3 q1_x VSSP VSSP nch W=0.6u L=0.18u
R_DONE3_OUT done3 done3_x 0.14
C_DONE3_OUT done3_x VSSP 0.9f
R_DONE4_IN q0 q0_x 0.1
C_DONE4_IN q0_x VSSP 0.7f
Mp_DONE4_P done4 q0_x VDDP VDDP pch W=1.2u L=0.18u
Mn_DONE4_N done4 q0_x VSSP VSSP nch W=0.6u L=0.18u
R_DONE4_OUT done4 done4_x 0.14
C_DONE4_OUT done4_x VSSP 0.9f
R_DONE12_A done1 done1_x 0.12
C_DONE12_A done1_x VSSP 0.6f
R_DONE12_B done2 done2_x 0.12
C_DONE12_B done2_x VSSP 0.6f
Mp_DONE12_P1 done12 done1_x VDDP VDDP pch W=1.6u L=0.18u
Mp_DONE12_P2 done12 done2_x VDDP VDDP pch W=1.6u L=0.18u
Mn_DONE12_N1 done12 done1_x DONE12_n1 VSSP nch W=1.0u L=0.18u
Mn_DONE12_N2 DONE12_n1 done2_x VSSP VSSP nch W=1.0u L=0.18u
R_DONE12_OUT done12 done12_x 0.16
C_DONE12_OUT done12_x VSSP 1.0f
R_DONE34_A done3 done3_x 0.12
C_DONE34_A done3_x VSSP 0.6f
R_DONE34_B done4 done4_x 0.12
C_DONE34_B done4_x VSSP 0.6f
Mp_DONE34_P1 done34 done3_x VDDP VDDP pch W=1.6u L=0.18u
Mp_DONE34_P2 done34 done4_x VDDP VDDP pch W=1.6u L=0.18u
Mn_DONE34_N1 done34 done3_x DONE34_n1 VSSP nch W=1.0u L=0.18u
Mn_DONE34_N2 DONE34_n1 done4_x VSSP VSSP nch W=1.0u L=0.18u
R_DONE34_OUT done34 done34_x 0.16
C_DONE34_OUT done34_x VSSP 1.0f
R_DONEFIN_A done12 done12_x 0.12
C_DONEFIN_A done12_x VSSP 0.6f
R_DONEFIN_B done34 done34_x 0.12
C_DONEFIN_B done34_x VSSP 0.6f
Mp_DONEFIN_P1 DONE done12_x VDDP VDDP pch W=1.6u L=0.18u
Mp_DONEFIN_P2 DONE done34_x VDDP VDDP pch W=1.6u L=0.18u
Mn_DONEFIN_N1 DONE done12_x DONEFIN_n1 VSSP nch W=1.0u L=0.18u
Mn_DONEFIN_N2 DONEFIN_n1 done34_x VSSP VSSP nch W=1.0u L=0.18u
R_DONEFIN_OUT DONE DONE_x 0.16
C_DONEFIN_OUT DONE_x VSSP 1.0f

* Top-level flattened instances / probes
C_DONE DONE VSSP 0.7f
C_OUTP OUTP VSSP 20f
C_OUTN OUTN VSSP 20f

.op
.tran 1n 100n
.measure tran vcomp_pp pp v(COMPx) from=1u to=2u
.measure tran vdone_final find v(DONE) at=100n
.end

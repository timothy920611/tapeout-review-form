* 4-bit SAR ADC clean pre-layout netlist
.option post=2 nomod
.temp 27
.param Lmin=0.18u
.model nch nmos level=1 vto=0.45 kp=220u lambda=0.05
.model pch pmos level=1 vto=-0.45 kp=85u lambda=0.06
VDD VDD 0 1.8
VSS VSS 0 0
VCM VCM 0 0.9
VREFP VREFP 0 1.2
VREFN VREFN 0 0.6
VINP VINP 0 0.9
VINN VINN 0 0.9
VCLK CLK 0 PULSE(0 1.8 0 50p 50p 5n 10n)
VSTART START 0 PULSE(0 1.8 2n 50p 50p 20n 40n)
CLOADP OUTP 0 20f
CLOADN OUTN 0 20f
COUT3 OUT3 0 5f
COUT2 OUT2 0 5f
COUT1 OUT1 0 5f
COUT0 OUT0 0 5f
CDBUS DONE 0 5f
.subckt INV A Y VDD VSS
Mp1 Y A VDD VDD pch W=1.2u L=0.18u
Mn1 Y A VSS VSS nch W=0.6u L=0.18u
.ends INV
.subckt NAND2 A B Y VDD VSS
Mp1 Y A VDD VDD pch W=1.6u L=0.18u
Mp2 Y B VDD VDD pch W=1.6u L=0.18u
Mn1 Y A n1 VSS nch W=1.0u L=0.18u
Mn2 n1 B VSS VSS nch W=1.0u L=0.18u
.ends NAND2
.subckt NOR2 A B Y VDD VSS
Mp1 n1 A VDD VDD pch W=1.6u L=0.18u
Mp2 Y B n1 VDD pch W=1.6u L=0.18u
Mn1 Y A VSS VSS nch W=1.0u L=0.18u
Mn2 Y B VSS VSS nch W=1.0u L=0.18u
.ends NOR2
.subckt TG IN OUT EN ENB VDD VSS
Mp1 OUT ENB IN VDD pch W=1.6u L=0.18u
Mn1 OUT EN IN VSS nch W=1.0u L=0.18u
.ends TG
.subckt DLATCH D CLK CLKB Q QB VDD VSS
Xtg1 D n1 CLK CLKB VDD VSS TG
Xinv1 n1 n2 VDD VSS INV
Xtg2 n2 n3 CLKB CLK VDD VSS TG
Xinv2 n3 Q VDD VSS INV
Xinv3 Q QB VDD VSS INV
Xbuf1 QB QBUF VDD VSS INV
Rkeep Q QBUF 10Meg
.ends DLATCH
.subckt DFF D CLK CLKB Q QB VDD VSS
Xl1 D CLK CLKB n1 n1b VDD VSS DLATCH
Xl2 n1 CLK CLKB Q QB VDD VSS DLATCH
.ends DFF
.subckt SA_COMP INP INN CLK OUTP OUTN VDD VSS
Mn1 net1 CLK VSS VSS nch W=6u L=0.18u
Mn2 net2 CLK VSS VSS nch W=6u L=0.18u
Mn3 OUTP INN net1 VSS nch W=4u L=0.18u
Mn4 OUTN INP net2 VSS nch W=4u L=0.18u
Mn5 net1 INP tail VSS nch W=3u L=0.18u
Mn6 net2 INN tail VSS nch W=3u L=0.18u
Mn7 tail CLK VSS VSS nch W=8u L=0.18u
Mp1 OUTP CLK VDD VDD pch W=4u L=0.18u
Mp2 OUTN CLK VDD VDD pch W=4u L=0.18u
Mp3 net1 RST VDD VDD pch W=2u L=0.18u
Mp4 net2 RST VDD VDD pch W=2u L=0.18u
Mp5 RST CLK VDD VDD pch W=2u L=0.18u
C1 OUTP VSS 12f
C2 OUTN VSS 12f
R1 OUTP VSS 2Meg
R2 OUTN VSS 2Meg
.ends SA_COMP
.subckt CDAC_BIT_3 TOP BOT SWP SWN VREFP VREFN VCM VDD VSS
Cmain TOP BOT 8f
Cbot BOT VSS 0.8f
Rswp SWP TOP 0.22
RswN SWN BOT 0.22
Rleak BOT VSS 50Meg
.ends CDAC_BIT_3
.subckt CDAC_BIT_2 TOP BOT SWP SWN VREFP VREFN VCM VDD VSS
Cmain TOP BOT 4f
Cbot BOT VSS 0.8f
Rswp SWP TOP 0.22
RswN SWN BOT 0.22
Rleak BOT VSS 50Meg
.ends CDAC_BIT_2
.subckt CDAC_BIT_1 TOP BOT SWP SWN VREFP VREFN VCM VDD VSS
Cmain TOP BOT 2f
Cbot BOT VSS 0.8f
Rswp SWP TOP 0.22
RswN SWN BOT 0.22
Rleak BOT VSS 50Meg
.ends CDAC_BIT_1
.subckt CDAC_BIT_0 TOP BOT SWP SWN VREFP VREFN VCM VDD VSS
Cmain TOP BOT 1f
Cbot BOT VSS 0.8f
Rswp SWP TOP 0.22
RswN SWN BOT 0.22
Rleak BOT VSS 50Meg
.ends CDAC_BIT_0
.subckt CDAC4 DACP DACN SWP3 SWN3 SWP2 SWN2 SWP1 SWN1 SWP0 SWN0 VREFP VREFN VCM VDD VSS
Xb3 DACP n3p SWP3 SWN3 VREFP VREFN VCM VDD VSS CDAC_BIT_3
Xb2 n3p n2p SWP2 SWN2 VREFP VREFN VCM VDD VSS CDAC_BIT_2
Xb1 n2p n1p SWP1 SWN1 VREFP VREFN VCM VDD VSS CDAC_BIT_1
Xb0 n1p n0p SWP0 SWN0 VREFP VREFN VCM VDD VSS CDAC_BIT_0
Xc3 DACN n3n SWP3 SWN3 VREFP VREFN VCM VDD VSS CDAC_BIT_3
Xc2 n3n n2n SWP2 SWN2 VREFP VREFN VCM VDD VSS CDAC_BIT_2
Xc1 n2n n1n SWP1 SWN1 VREFP VREFN VCM VDD VSS CDAC_BIT_1
Xc0 n1n n0n SWP0 SWN0 VREFP VREFN VCM VDD VSS CDAC_BIT_0
Rcmp_p DACP n3p 0.15
Rcmp_n DACN n3n 0.15
Ccm_p n0p VSS 4f
Ccm_n n0n VSS 4f
.ends CDAC4
XSA SA_INP SA_INN CLK COMP COMPB VDD VSS SA_COMP
RINP VINP SA_INP 0.35
RINN VINN SA_INN 0.35
CCOMP COMP VSS 3f
CCOMPB COMPB VSS 3f
XCDAC SA_INP SA_INN SWP3 SWN3 SWP2 SWN2 SWP1 SWN1 SWP0 SWN0 VREFP VREFN VCM VDD VSS CDAC4
XSAR CLK START DONE COMP OUT3 OUT2 OUT1 OUT0 VDD VSS SAR_CTRL4
Rswp3 SWP3 0 100Meg
Rswp2 SWP2 0 100Meg
Rswp1 SWP1 0 100Meg
Rswp0 SWP0 0 100Meg
RswN3 SWN3 0 100Meg
Rswn2 SWN2 0 100Meg
Rswn1 SWN1 0 100Meg
Rswn0 SWN0 0 100Meg
.op
.tran 1n 100n
.measure tran vcomp_pp pp v(COMP) from=1u to=2u
.end

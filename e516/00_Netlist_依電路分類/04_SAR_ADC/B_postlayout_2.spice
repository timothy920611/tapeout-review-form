* 4-bit SAR ADC fully flattened post-layout netlist
.option post=2 nomod
.temp 27
.param Lmin=0.18u
.model nch nmos level=1 vto=0.45 kp=220u lambda=0.05
.model pch pmos level=1 vto=-0.45 kp=85u lambda=0.06
VDD VDD 0 1.8
VSS VSS 0 0
VCM VCM 0 0.9
VREFP VREFP 0 1.2
VREFN VREFN 0 0.6
VINP VINP 0 0.9
VINN VINN 0 0.9
VCLK CLK 0 PULSE(0 1.8 0 50p 50p 5n 10n)
VSTART START 0 PULSE(0 1.8 2n 50p 50p 20n 40n)

* package / routing parasitics
RPKG_VDD VDD VDDP 0.18
RPKG_VSS VSS VSSP 0.16
CPKG_VDD VDDP VSSP 120f
CPKG_VSS VSSP 0 30f
RPKG_CLK CLK CLK1 0.28
RPKG_START START START1 0.24
RPKG_INP VINP VINP1 0.35
RPKG_INN VINN VINN1 0.35
RPKG_VREFP VREFP VREFP1 0.22
RPKG_VREFN VREFN VREFN1 0.22
CPKG_CLK CLK1 VSSP 4f
CPKG_START START1 VSSP 2f
CPKG_INP VINP1 VSSP 10f
CPKG_INN VINN1 VSSP 10f
CPKG_VREFP VREFP1 VSSP 8f
CPKG_VREFN VREFN1 VSSP 8f
RINP VINP1 SA_INP 0.35
RINN VINN1 SA_INN 0.35
CCOMP COMP VSSP 3f
CCOMPB COMPB VSSP 3f

Mn_SA1 net1 CLK VSSP VSSP nch W=6u L=Lmin
Mn_SA2 net2 CLK VSSP VSSP nch W=6u L=Lmin
Mn_SA3 COMP INN net1 VSSP nch W=4u L=Lmin
Mn_SA4 COMPB INP net2 VSSP nch W=4u L=Lmin
Mn_SA5 net1 INP tail VSSP nch W=3u L=Lmin
Mn_SA6 net2 INN tail VSSP nch W=3u L=Lmin
Mn_SA7 tail CLK VSSP VSSP nch W=8u L=Lmin
Mp_SA1 COMP CLK VDDP VDDP pch W=4u L=Lmin
Mp_SA2 COMPB CLK VDDP VDDP pch W=4u L=Lmin
Mp_SA3 net1 RST VDDP VDDP pch W=2u L=Lmin
Mp_SA4 net2 RST VDDP VDDP pch W=2u L=Lmin
Mp_SA5 RST CLK VDDP VDDP pch W=2u L=Lmin
R_SA1 COMP VSSP 2Meg
R_SA2 COMPB VSSP 2Meg
C_SA1 COMP VSSP 12f
C_SA2 COMPB VSSP 12f

RCDAC_P_0 SA_INP SA_INP1 0.20
RCDAC_P_1 SA_INP1 n3p 0.08
C_CDAC_P_0 SA_INP1 VSSP 1.0f
RCDAC_P_2 n3p n2p 0.06
RCDAC_P_3 n2p n1p 0.05
RCDAC_P_4 n1p n0p 0.04
C_CDAC_P_1 n3p VSSP 0.8f
C_CDAC_P_2 n2p VSSP 0.7f
C_CDAC_P_3 n1p VSSP 0.6f
C_CDAC_P_4 n0p VSSP 0.5f
CMAIN_P_3 n3p n2p 4f
CMAIN_P_2 n2p n1p 2f
CMAIN_P_1 n1p n0p 1f
RLEAK_P_3 n3p VSSP 50Meg
RLEAK_P_2 n2p VSSP 50Meg
RLEAK_P_1 n1p VSSP 50Meg
RLEAK_P_0 n0p VSSP 50Meg
RCDAC_N_0 SA_INN SA_INN1 0.20
RCDAC_N_1 SA_INN1 n3n 0.08
C_CDAC_N_0 SA_INN1 VSSP 1.0f
RCDAC_N_2 n3n n2n 0.06
RCDAC_N_3 n2n n1n 0.05
RCDAC_N_4 n1n n0n 0.04
C_CDAC_N_1 n3n VSSP 0.8f
C_CDAC_N_2 n2n VSSP 0.7f
C_CDAC_N_3 n1n VSSP 0.6f
C_CDAC_N_4 n0n VSSP 0.5f
CMAIN_N_3 n3n n2n 4f
CMAIN_N_2 n2n n1n 2f
CMAIN_N_1 n1n n0n 1f
RLEAK_N_3 n3n VSSP 50Meg
RLEAK_N_2 n2n VSSP 50Meg
RLEAK_N_1 n1n VSSP 50Meg
RLEAK_N_0 n0n VSSP 50Meg

* flattened SAR controller logic
R_START_INV_GIN START1 START1_x 0.1
C_START_INV_GIN START1_x VSSP 0.8f
Mp_START_INV_P nst START1_x VDDP VDDP pch W=1.2u L=0.18u
Mn_START_INV_N nst START1_x VSSP VSSP nch W=0.6u L=0.18u
R_START_INV_GOUT nst nst_x 0.14
C_START_INV_GOUT nst_x VSSP 1.0f
R_CLK_INV_GIN CLK1 CLK1_x 0.1
C_CLK_INV_GIN CLK1_x VSSP 0.8f
Mp_CLK_INV_P CLKB CLK1_x VDDP VDDP pch W=1.2u L=0.18u
Mn_CLK_INV_N CLKB CLK1_x VSSP VSSP nch W=0.6u L=0.18u
R_CLK_INV_GOUT CLKB CLKB_x 0.14
C_CLK_INV_GOUT CLKB_x VSSP 1.0f
R_DFF3_L1_TG1_EN CLK1 CLK1_x 0.08
R_DFF3_L1_TG1_ENB CLKB CLKB_x 0.08
C_DFF3_L1_TG1_EN CLK1_x VSSP 0.6f
C_DFF3_L1_TG1_ENB CLKB_x VSSP 0.6f
Mp_DFF3_L1_TG1_P DFF3_L1_n1 CLKB_x d3 VDDP pch W=1.6u L=0.18u
Mn_DFF3_L1_TG1_N DFF3_L1_n1 CLK1_x d3 VSSP nch W=1.0u L=0.18u
R_DFF3_L1_TG1_IO d3 DFF3_L1_n1 0.05
C_DFF3_L1_TG1_IO DFF3_L1_n1 VSSP 0.5f
R_DFF3_L1_INV1_GIN DFF3_L1_n1 DFF3_L1_n1_x 0.1
C_DFF3_L1_INV1_GIN DFF3_L1_n1_x VSSP 0.8f
Mp_DFF3_L1_INV1_P DFF3_L1_n2 DFF3_L1_n1_x VDDP VDDP pch W=1.2u L=0.18u
Mn_DFF3_L1_INV1_N DFF3_L1_n2 DFF3_L1_n1_x VSSP VSSP nch W=0.6u L=0.18u
R_DFF3_L1_INV1_GOUT DFF3_L1_n2 DFF3_L1_n2_x 0.14
C_DFF3_L1_INV1_GOUT DFF3_L1_n2_x VSSP 1.0f
R_DFF3_L1_TG2_EN CLKB CLKB_x 0.08
R_DFF3_L1_TG2_ENB CLK1 CLK1_x 0.08
C_DFF3_L1_TG2_EN CLKB_x VSSP 0.6f
C_DFF3_L1_TG2_ENB CLK1_x VSSP 0.6f
Mp_DFF3_L1_TG2_P DFF3_L1_n3 CLK1_x DFF3_L1_n2 VDDP pch W=1.6u L=0.18u
Mn_DFF3_L1_TG2_N DFF3_L1_n3 CLKB_x DFF3_L1_n2 VSSP nch W=1.0u L=0.18u
R_DFF3_L1_TG2_IO DFF3_L1_n2 DFF3_L1_n3 0.05
C_DFF3_L1_TG2_IO DFF3_L1_n3 VSSP 0.5f
R_DFF3_L1_INV2_GIN DFF3_L1_n3 DFF3_L1_n3_x 0.1
C_DFF3_L1_INV2_GIN DFF3_L1_n3_x VSSP 0.8f
Mp_DFF3_L1_INV2_P DFF3_m DFF3_L1_n3_x VDDP VDDP pch W=1.2u L=0.18u
Mn_DFF3_L1_INV2_N DFF3_m DFF3_L1_n3_x VSSP VSSP nch W=0.6u L=0.18u
R_DFF3_L1_INV2_GOUT DFF3_m DFF3_m_x 0.14
C_DFF3_L1_INV2_GOUT DFF3_m_x VSSP 1.0f
R_DFF3_L1_INV3_GIN DFF3_m DFF3_m_x 0.1
C_DFF3_L1_INV3_GIN DFF3_m_x VSSP 0.8f
Mp_DFF3_L1_INV3_P DFF3_mb DFF3_m_x VDDP VDDP pch W=1.2u L=0.18u
Mn_DFF3_L1_INV3_N DFF3_mb DFF3_m_x VSSP VSSP nch W=0.6u L=0.18u
R_DFF3_L1_INV3_GOUT DFF3_mb DFF3_mb_x 0.14
C_DFF3_L1_INV3_GOUT DFF3_mb_x VSSP 1.0f
R_DFF3_L1_KEEP DFF3_m DFF3_L1_keep 10Meg
C_DFF3_L1_KEEP DFF3_L1_keep VSSP 0.2f
R_DFF3_L2_TG1_EN CLK1 CLK1_x 0.08
R_DFF3_L2_TG1_ENB CLKB CLKB_x 0.08
C_DFF3_L2_TG1_EN CLK1_x VSSP 0.6f
C_DFF3_L2_TG1_ENB CLKB_x VSSP 0.6f
Mp_DFF3_L2_TG1_P DFF3_L2_n1 CLKB_x DFF3_m VDDP pch W=1.6u L=0.18u
Mn_DFF3_L2_TG1_N DFF3_L2_n1 CLK1_x DFF3_m VSSP nch W=1.0u L=0.18u
R_DFF3_L2_TG1_IO DFF3_m DFF3_L2_n1 0.05
C_DFF3_L2_TG1_IO DFF3_L2_n1 VSSP 0.5f
R_DFF3_L2_INV1_GIN DFF3_L2_n1 DFF3_L2_n1_x 0.1
C_DFF3_L2_INV1_GIN DFF3_L2_n1_x VSSP 0.8f
Mp_DFF3_L2_INV1_P DFF3_L2_n2 DFF3_L2_n1_x VDDP VDDP pch W=1.2u L=0.18u
Mn_DFF3_L2_INV1_N DFF3_L2_n2 DFF3_L2_n1_x VSSP VSSP nch W=0.6u L=0.18u
R_DFF3_L2_INV1_GOUT DFF3_L2_n2 DFF3_L2_n2_x 0.14
C_DFF3_L2_INV1_GOUT DFF3_L2_n2_x VSSP 1.0f
R_DFF3_L2_TG2_EN CLKB CLKB_x 0.08
R_DFF3_L2_TG2_ENB CLK1 CLK1_x 0.08
C_DFF3_L2_TG2_EN CLKB_x VSSP 0.6f
C_DFF3_L2_TG2_ENB CLK1_x VSSP 0.6f
Mp_DFF3_L2_TG2_P DFF3_L2_n3 CLK1_x DFF3_L2_n2 VDDP pch W=1.6u L=0.18u
Mn_DFF3_L2_TG2_N DFF3_L2_n3 CLKB_x DFF3_L2_n2 VSSP nch W=1.0u L=0.18u
R_DFF3_L2_TG2_IO DFF3_L2_n2 DFF3_L2_n3 0.05
C_DFF3_L2_TG2_IO DFF3_L2_n3 VSSP 0.5f
R_DFF3_L2_INV2_GIN DFF3_L2_n3 DFF3_L2_n3_x 0.1
C_DFF3_L2_INV2_GIN DFF3_L2_n3_x VSSP 0.8f
Mp_DFF3_L2_INV2_P q3 DFF3_L2_n3_x VDDP VDDP pch W=1.2u L=0.18u
Mn_DFF3_L2_INV2_N q3 DFF3_L2_n3_x VSSP VSSP nch W=0.6u L=0.18u
R_DFF3_L2_INV2_GOUT q3 q3_x 0.14
C_DFF3_L2_INV2_GOUT q3_x VSSP 1.0f
R_DFF3_L2_INV3_GIN q3 q3_x 0.1
C_DFF3_L2_INV3_GIN q3_x VSSP 0.8f
Mp_DFF3_L2_INV3_P qb3 q3_x VDDP VDDP pch W=1.2u L=0.18u
Mn_DFF3_L2_INV3_N qb3 q3_x VSSP VSSP nch W=0.6u L=0.18u
R_DFF3_L2_INV3_GOUT qb3 qb3_x 0.14
C_DFF3_L2_INV3_GOUT qb3_x VSSP 1.0f
R_DFF3_L2_KEEP q3 DFF3_L2_keep 10Meg
C_DFF3_L2_KEEP DFF3_L2_keep VSSP 0.2f
R_DFF3_CLK CLK1 DFF3_clkx 0.09
C_DFF3_CLK DFF3_clkx VSSP 0.9f
R_NAND_D3_GA q3 q3_x 0.12
C_NAND_D3_GA q3_x VSSP 0.7f
R_NAND_D3_GB COMP COMP_x 0.12
C_NAND_D3_GB COMP_x VSSP 0.7f
Mp_NAND_D3_P1 d3 q3_x VDDP VDDP pch W=1.6u L=0.18u
Mp_NAND_D3_P2 d3 COMP_x VDDP VDDP pch W=1.6u L=0.18u
Mn_NAND_D3_N1 d3 q3_x NAND_D3_n1 VSSP nch W=1.0u L=0.18u
Mn_NAND_D3_N2 NAND_D3_n1 COMP_x VSSP VSSP nch W=1.0u L=0.18u
R_NAND_D3_GOUT d3 d3_x 0.16
C_NAND_D3_GOUT d3_x VSSP 1.0f
R_NAND_OUT3_GA nst nst_x 0.12
C_NAND_OUT3_GA nst_x VSSP 0.7f
R_NAND_OUT3_GB q3 q3_x 0.12
C_NAND_OUT3_GB q3_x VSSP 0.7f
Mp_NAND_OUT3_P1 out3 nst_x VDDP VDDP pch W=1.6u L=0.18u
Mp_NAND_OUT3_P2 out3 q3_x VDDP VDDP pch W=1.6u L=0.18u
Mn_NAND_OUT3_N1 out3 nst_x NAND_OUT3_n1 VSSP nch W=1.0u L=0.18u
Mn_NAND_OUT3_N2 NAND_OUT3_n1 q3_x VSSP VSSP nch W=1.0u L=0.18u
R_NAND_OUT3_GOUT out3 out3_x 0.16
C_NAND_OUT3_GOUT out3_x VSSP 1.0f
R_OUTBUF3_A_GIN out3 out3_x 0.1
C_OUTBUF3_A_GIN out3_x VSSP 0.8f
Mp_OUTBUF3_A_P OUT3_i out3_x VDDP VDDP pch W=1.2u L=0.18u
Mn_OUTBUF3_A_N OUT3_i out3_x VSSP VSSP nch W=0.6u L=0.18u
R_OUTBUF3_A_GOUT OUT3_i OUT3_i_x 0.14
C_OUTBUF3_A_GOUT OUT3_i_x VSSP 1.0f
R_OUTBUF3_B_GIN OUT3_i OUT3_i_x 0.1
C_OUTBUF3_B_GIN OUT3_i_x VSSP 0.8f
Mp_OUTBUF3_B_P OUT3 OUT3_i_x VDDP VDDP pch W=1.2u L=0.18u
Mn_OUTBUF3_B_N OUT3 OUT3_i_x VSSP VSSP nch W=0.6u L=0.18u
R_OUTBUF3_B_GOUT OUT3 OUT3_x 0.14
C_OUTBUF3_B_GOUT OUT3_x VSSP 1.0f
R_OUT3_TR OUT3_i OUT3_x 0.13
C_OUT3_TR OUT3_x VSSP 0.8f
R_DFF2_L1_TG1_EN CLK1 CLK1_x 0.08
R_DFF2_L1_TG1_ENB CLKB CLKB_x 0.08
C_DFF2_L1_TG1_EN CLK1_x VSSP 0.6f
C_DFF2_L1_TG1_ENB CLKB_x VSSP 0.6f
Mp_DFF2_L1_TG1_P DFF2_L1_n1 CLKB_x d2 VDDP pch W=1.6u L=0.18u
Mn_DFF2_L1_TG1_N DFF2_L1_n1 CLK1_x d2 VSSP nch W=1.0u L=0.18u
R_DFF2_L1_TG1_IO d2 DFF2_L1_n1 0.05
C_DFF2_L1_TG1_IO DFF2_L1_n1 VSSP 0.5f
R_DFF2_L1_INV1_GIN DFF2_L1_n1 DFF2_L1_n1_x 0.1
C_DFF2_L1_INV1_GIN DFF2_L1_n1_x VSSP 0.8f
Mp_DFF2_L1_INV1_P DFF2_L1_n2 DFF2_L1_n1_x VDDP VDDP pch W=1.2u L=0.18u
Mn_DFF2_L1_INV1_N DFF2_L1_n2 DFF2_L1_n1_x VSSP VSSP nch W=0.6u L=0.18u
R_DFF2_L1_INV1_GOUT DFF2_L1_n2 DFF2_L1_n2_x 0.14
C_DFF2_L1_INV1_GOUT DFF2_L1_n2_x VSSP 1.0f
R_DFF2_L1_TG2_EN CLKB CLKB_x 0.08
R_DFF2_L1_TG2_ENB CLK1 CLK1_x 0.08
C_DFF2_L1_TG2_EN CLKB_x VSSP 0.6f
C_DFF2_L1_TG2_ENB CLK1_x VSSP 0.6f
Mp_DFF2_L1_TG2_P DFF2_L1_n3 CLK1_x DFF2_L1_n2 VDDP pch W=1.6u L=0.18u
Mn_DFF2_L1_TG2_N DFF2_L1_n3 CLKB_x DFF2_L1_n2 VSSP nch W=1.0u L=0.18u
R_DFF2_L1_TG2_IO DFF2_L1_n2 DFF2_L1_n3 0.05
C_DFF2_L1_TG2_IO DFF2_L1_n3 VSSP 0.5f
R_DFF2_L1_INV2_GIN DFF2_L1_n3 DFF2_L1_n3_x 0.1
C_DFF2_L1_INV2_GIN DFF2_L1_n3_x VSSP 0.8f
Mp_DFF2_L1_INV2_P DFF2_m DFF2_L1_n3_x VDDP VDDP pch W=1.2u L=0.18u
Mn_DFF2_L1_INV2_N DFF2_m DFF2_L1_n3_x VSSP VSSP nch W=0.6u L=0.18u
R_DFF2_L1_INV2_GOUT DFF2_m DFF2_m_x 0.14
C_DFF2_L1_INV2_GOUT DFF2_m_x VSSP 1.0f
R_DFF2_L1_INV3_GIN DFF2_m DFF2_m_x 0.1
C_DFF2_L1_INV3_GIN DFF2_m_x VSSP 0.8f
Mp_DFF2_L1_INV3_P DFF2_mb DFF2_m_x VDDP VDDP pch W=1.2u L=0.18u
Mn_DFF2_L1_INV3_N DFF2_mb DFF2_m_x VSSP VSSP nch W=0.6u L=0.18u
R_DFF2_L1_INV3_GOUT DFF2_mb DFF2_mb_x 0.14
C_DFF2_L1_INV3_GOUT DFF2_mb_x VSSP 1.0f
R_DFF2_L1_KEEP DFF2_m DFF2_L1_keep 10Meg
C_DFF2_L1_KEEP DFF2_L1_keep VSSP 0.2f
R_DFF2_L2_TG1_EN CLK1 CLK1_x 0.08
R_DFF2_L2_TG1_ENB CLKB CLKB_x 0.08
C_DFF2_L2_TG1_EN CLK1_x VSSP 0.6f
C_DFF2_L2_TG1_ENB CLKB_x VSSP 0.6f
Mp_DFF2_L2_TG1_P DFF2_L2_n1 CLKB_x DFF2_m VDDP pch W=1.6u L=0.18u
Mn_DFF2_L2_TG1_N DFF2_L2_n1 CLK1_x DFF2_m VSSP nch W=1.0u L=0.18u
R_DFF2_L2_TG1_IO DFF2_m DFF2_L2_n1 0.05
C_DFF2_L2_TG1_IO DFF2_L2_n1 VSSP 0.5f
R_DFF2_L2_INV1_GIN DFF2_L2_n1 DFF2_L2_n1_x 0.1
C_DFF2_L2_INV1_GIN DFF2_L2_n1_x VSSP 0.8f
Mp_DFF2_L2_INV1_P DFF2_L2_n2 DFF2_L2_n1_x VDDP VDDP pch W=1.2u L=0.18u
Mn_DFF2_L2_INV1_N DFF2_L2_n2 DFF2_L2_n1_x VSSP VSSP nch W=0.6u L=0.18u
R_DFF2_L2_INV1_GOUT DFF2_L2_n2 DFF2_L2_n2_x 0.14
C_DFF2_L2_INV1_GOUT DFF2_L2_n2_x VSSP 1.0f
R_DFF2_L2_TG2_EN CLKB CLKB_x 0.08
R_DFF2_L2_TG2_ENB CLK1 CLK1_x 0.08
C_DFF2_L2_TG2_EN CLKB_x VSSP 0.6f
C_DFF2_L2_TG2_ENB CLK1_x VSSP 0.6f
Mp_DFF2_L2_TG2_P DFF2_L2_n3 CLK1_x DFF2_L2_n2 VDDP pch W=1.6u L=0.18u
Mn_DFF2_L2_TG2_N DFF2_L2_n3 CLKB_x DFF2_L2_n2 VSSP nch W=1.0u L=0.18u
R_DFF2_L2_TG2_IO DFF2_L2_n2 DFF2_L2_n3 0.05
C_DFF2_L2_TG2_IO DFF2_L2_n3 VSSP 0.5f
R_DFF2_L2_INV2_GIN DFF2_L2_n3 DFF2_L2_n3_x 0.1
C_DFF2_L2_INV2_GIN DFF2_L2_n3_x VSSP 0.8f
Mp_DFF2_L2_INV2_P q2 DFF2_L2_n3_x VDDP VDDP pch W=1.2u L=0.18u
Mn_DFF2_L2_INV2_N q2 DFF2_L2_n3_x VSSP VSSP nch W=0.6u L=0.18u
R_DFF2_L2_INV2_GOUT q2 q2_x 0.14
C_DFF2_L2_INV2_GOUT q2_x VSSP 1.0f
R_DFF2_L2_INV3_GIN q2 q2_x 0.1
C_DFF2_L2_INV3_GIN q2_x VSSP 0.8f
Mp_DFF2_L2_INV3_P qb2 q2_x VDDP VDDP pch W=1.2u L=0.18u
Mn_DFF2_L2_INV3_N qb2 q2_x VSSP VSSP nch W=0.6u L=0.18u
R_DFF2_L2_INV3_GOUT qb2 qb2_x 0.14
C_DFF2_L2_INV3_GOUT qb2_x VSSP 1.0f
R_DFF2_L2_KEEP q2 DFF2_L2_keep 10Meg
C_DFF2_L2_KEEP DFF2_L2_keep VSSP 0.2f
R_DFF2_CLK CLK1 DFF2_clkx 0.09
C_DFF2_CLK DFF2_clkx VSSP 0.9f
R_NAND_D2_GA q2 q2_x 0.12
C_NAND_D2_GA q2_x VSSP 0.7f
R_NAND_D2_GB COMP COMP_x 0.12
C_NAND_D2_GB COMP_x VSSP 0.7f
Mp_NAND_D2_P1 d2 q2_x VDDP VDDP pch W=1.6u L=0.18u
Mp_NAND_D2_P2 d2 COMP_x VDDP VDDP pch W=1.6u L=0.18u
Mn_NAND_D2_N1 d2 q2_x NAND_D2_n1 VSSP nch W=1.0u L=0.18u
Mn_NAND_D2_N2 NAND_D2_n1 COMP_x VSSP VSSP nch W=1.0u L=0.18u
R_NAND_D2_GOUT d2 d2_x 0.16
C_NAND_D2_GOUT d2_x VSSP 1.0f
R_NAND_OUT2_GA nst nst_x 0.12
C_NAND_OUT2_GA nst_x VSSP 0.7f
R_NAND_OUT2_GB q2 q2_x 0.12
C_NAND_OUT2_GB q2_x VSSP 0.7f
Mp_NAND_OUT2_P1 out2 nst_x VDDP VDDP pch W=1.6u L=0.18u
Mp_NAND_OUT2_P2 out2 q2_x VDDP VDDP pch W=1.6u L=0.18u
Mn_NAND_OUT2_N1 out2 nst_x NAND_OUT2_n1 VSSP nch W=1.0u L=0.18u
Mn_NAND_OUT2_N2 NAND_OUT2_n1 q2_x VSSP VSSP nch W=1.0u L=0.18u
R_NAND_OUT2_GOUT out2 out2_x 0.16
C_NAND_OUT2_GOUT out2_x VSSP 1.0f
R_OUTBUF2_A_GIN out2 out2_x 0.1
C_OUTBUF2_A_GIN out2_x VSSP 0.8f
Mp_OUTBUF2_A_P OUT2_i out2_x VDDP VDDP pch W=1.2u L=0.18u
Mn_OUTBUF2_A_N OUT2_i out2_x VSSP VSSP nch W=0.6u L=0.18u
R_OUTBUF2_A_GOUT OUT2_i OUT2_i_x 0.14
C_OUTBUF2_A_GOUT OUT2_i_x VSSP 1.0f
R_OUTBUF2_B_GIN OUT2_i OUT2_i_x 0.1
C_OUTBUF2_B_GIN OUT2_i_x VSSP 0.8f
Mp_OUTBUF2_B_P OUT2 OUT2_i_x VDDP VDDP pch W=1.2u L=0.18u
Mn_OUTBUF2_B_N OUT2 OUT2_i_x VSSP VSSP nch W=0.6u L=0.18u
R_OUTBUF2_B_GOUT OUT2 OUT2_x 0.14
C_OUTBUF2_B_GOUT OUT2_x VSSP 1.0f
R_OUT2_TR OUT2_i OUT2_x 0.13
C_OUT2_TR OUT2_x VSSP 0.8f
R_DFF1_L1_TG1_EN CLK1 CLK1_x 0.08
R_DFF1_L1_TG1_ENB CLKB CLKB_x 0.08
C_DFF1_L1_TG1_EN CLK1_x VSSP 0.6f
C_DFF1_L1_TG1_ENB CLKB_x VSSP 0.6f
Mp_DFF1_L1_TG1_P DFF1_L1_n1 CLKB_x d1 VDDP pch W=1.6u L=0.18u
Mn_DFF1_L1_TG1_N DFF1_L1_n1 CLK1_x d1 VSSP nch W=1.0u L=0.18u
R_DFF1_L1_TG1_IO d1 DFF1_L1_n1 0.05
C_DFF1_L1_TG1_IO DFF1_L1_n1 VSSP 0.5f
R_DFF1_L1_INV1_GIN DFF1_L1_n1 DFF1_L1_n1_x 0.1
C_DFF1_L1_INV1_GIN DFF1_L1_n1_x VSSP 0.8f
Mp_DFF1_L1_INV1_P DFF1_L1_n2 DFF1_L1_n1_x VDDP VDDP pch W=1.2u L=0.18u
Mn_DFF1_L1_INV1_N DFF1_L1_n2 DFF1_L1_n1_x VSSP VSSP nch W=0.6u L=0.18u
R_DFF1_L1_INV1_GOUT DFF1_L1_n2 DFF1_L1_n2_x 0.14
C_DFF1_L1_INV1_GOUT DFF1_L1_n2_x VSSP 1.0f
R_DFF1_L1_TG2_EN CLKB CLKB_x 0.08
R_DFF1_L1_TG2_ENB CLK1 CLK1_x 0.08
C_DFF1_L1_TG2_EN CLKB_x VSSP 0.6f
C_DFF1_L1_TG2_ENB CLK1_x VSSP 0.6f
Mp_DFF1_L1_TG2_P DFF1_L1_n3 CLK1_x DFF1_L1_n2 VDDP pch W=1.6u L=0.18u
Mn_DFF1_L1_TG2_N DFF1_L1_n3 CLKB_x DFF1_L1_n2 VSSP nch W=1.0u L=0.18u
R_DFF1_L1_TG2_IO DFF1_L1_n2 DFF1_L1_n3 0.05
C_DFF1_L1_TG2_IO DFF1_L1_n3 VSSP 0.5f
R_DFF1_L1_INV2_GIN DFF1_L1_n3 DFF1_L1_n3_x 0.1
C_DFF1_L1_INV2_GIN DFF1_L1_n3_x VSSP 0.8f
Mp_DFF1_L1_INV2_P DFF1_m DFF1_L1_n3_x VDDP VDDP pch W=1.2u L=0.18u
Mn_DFF1_L1_INV2_N DFF1_m DFF1_L1_n3_x VSSP VSSP nch W=0.6u L=0.18u
R_DFF1_L1_INV2_GOUT DFF1_m DFF1_m_x 0.14
C_DFF1_L1_INV2_GOUT DFF1_m_x VSSP 1.0f
R_DFF1_L1_INV3_GIN DFF1_m DFF1_m_x 0.1
C_DFF1_L1_INV3_GIN DFF1_m_x VSSP 0.8f
Mp_DFF1_L1_INV3_P DFF1_mb DFF1_m_x VDDP VDDP pch W=1.2u L=0.18u
Mn_DFF1_L1_INV3_N DFF1_mb DFF1_m_x VSSP VSSP nch W=0.6u L=0.18u
R_DFF1_L1_INV3_GOUT DFF1_mb DFF1_mb_x 0.14
C_DFF1_L1_INV3_GOUT DFF1_mb_x VSSP 1.0f
R_DFF1_L1_KEEP DFF1_m DFF1_L1_keep 10Meg
C_DFF1_L1_KEEP DFF1_L1_keep VSSP 0.2f
R_DFF1_L2_TG1_EN CLK1 CLK1_x 0.08
R_DFF1_L2_TG1_ENB CLKB CLKB_x 0.08
C_DFF1_L2_TG1_EN CLK1_x VSSP 0.6f
C_DFF1_L2_TG1_ENB CLKB_x VSSP 0.6f
Mp_DFF1_L2_TG1_P DFF1_L2_n1 CLKB_x DFF1_m VDDP pch W=1.6u L=0.18u
Mn_DFF1_L2_TG1_N DFF1_L2_n1 CLK1_x DFF1_m VSSP nch W=1.0u L=0.18u
R_DFF1_L2_TG1_IO DFF1_m DFF1_L2_n1 0.05
C_DFF1_L2_TG1_IO DFF1_L2_n1 VSSP 0.5f
R_DFF1_L2_INV1_GIN DFF1_L2_n1 DFF1_L2_n1_x 0.1
C_DFF1_L2_INV1_GIN DFF1_L2_n1_x VSSP 0.8f
Mp_DFF1_L2_INV1_P DFF1_L2_n2 DFF1_L2_n1_x VDDP VDDP pch W=1.2u L=0.18u
Mn_DFF1_L2_INV1_N DFF1_L2_n2 DFF1_L2_n1_x VSSP VSSP nch W=0.6u L=0.18u
R_DFF1_L2_INV1_GOUT DFF1_L2_n2 DFF1_L2_n2_x 0.14
C_DFF1_L2_INV1_GOUT DFF1_L2_n2_x VSSP 1.0f
R_DFF1_L2_TG2_EN CLKB CLKB_x 0.08
R_DFF1_L2_TG2_ENB CLK1 CLK1_x 0.08
C_DFF1_L2_TG2_EN CLKB_x VSSP 0.6f
C_DFF1_L2_TG2_ENB CLK1_x VSSP 0.6f
Mp_DFF1_L2_TG2_P DFF1_L2_n3 CLK1_x DFF1_L2_n2 VDDP pch W=1.6u L=0.18u
Mn_DFF1_L2_TG2_N DFF1_L2_n3 CLKB_x DFF1_L2_n2 VSSP nch W=1.0u L=0.18u
R_DFF1_L2_TG2_IO DFF1_L2_n2 DFF1_L2_n3 0.05
C_DFF1_L2_TG2_IO DFF1_L2_n3 VSSP 0.5f
R_DFF1_L2_INV2_GIN DFF1_L2_n3 DFF1_L2_n3_x 0.1
C_DFF1_L2_INV2_GIN DFF1_L2_n3_x VSSP 0.8f
Mp_DFF1_L2_INV2_P q1 DFF1_L2_n3_x VDDP VDDP pch W=1.2u L=0.18u
Mn_DFF1_L2_INV2_N q1 DFF1_L2_n3_x VSSP VSSP nch W=0.6u L=0.18u
R_DFF1_L2_INV2_GOUT q1 q1_x 0.14
C_DFF1_L2_INV2_GOUT q1_x VSSP 1.0f
R_DFF1_L2_INV3_GIN q1 q1_x 0.1
C_DFF1_L2_INV3_GIN q1_x VSSP 0.8f
Mp_DFF1_L2_INV3_P qb1 q1_x VDDP VDDP pch W=1.2u L=0.18u
Mn_DFF1_L2_INV3_N qb1 q1_x VSSP VSSP nch W=0.6u L=0.18u
R_DFF1_L2_INV3_GOUT qb1 qb1_x 0.14
C_DFF1_L2_INV3_GOUT qb1_x VSSP 1.0f
R_DFF1_L2_KEEP q1 DFF1_L2_keep 10Meg
C_DFF1_L2_KEEP DFF1_L2_keep VSSP 0.2f
R_DFF1_CLK CLK1 DFF1_clkx 0.09
C_DFF1_CLK DFF1_clkx VSSP 0.9f
R_NAND_D1_GA q1 q1_x 0.12
C_NAND_D1_GA q1_x VSSP 0.7f
R_NAND_D1_GB COMP COMP_x 0.12
C_NAND_D1_GB COMP_x VSSP 0.7f
Mp_NAND_D1_P1 d1 q1_x VDDP VDDP pch W=1.6u L=0.18u
Mp_NAND_D1_P2 d1 COMP_x VDDP VDDP pch W=1.6u L=0.18u
Mn_NAND_D1_N1 d1 q1_x NAND_D1_n1 VSSP nch W=1.0u L=0.18u
Mn_NAND_D1_N2 NAND_D1_n1 COMP_x VSSP VSSP nch W=1.0u L=0.18u
R_NAND_D1_GOUT d1 d1_x 0.16
C_NAND_D1_GOUT d1_x VSSP 1.0f
R_NAND_OUT1_GA nst nst_x 0.12
C_NAND_OUT1_GA nst_x VSSP 0.7f
R_NAND_OUT1_GB q1 q1_x 0.12
C_NAND_OUT1_GB q1_x VSSP 0.7f
Mp_NAND_OUT1_P1 out1 nst_x VDDP VDDP pch W=1.6u L=0.18u
Mp_NAND_OUT1_P2 out1 q1_x VDDP VDDP pch W=1.6u L=0.18u
Mn_NAND_OUT1_N1 out1 nst_x NAND_OUT1_n1 VSSP nch W=1.0u L=0.18u
Mn_NAND_OUT1_N2 NAND_OUT1_n1 q1_x VSSP VSSP nch W=1.0u L=0.18u
R_NAND_OUT1_GOUT out1 out1_x 0.16
C_NAND_OUT1_GOUT out1_x VSSP 1.0f
R_OUTBUF1_A_GIN out1 out1_x 0.1
C_OUTBUF1_A_GIN out1_x VSSP 0.8f
Mp_OUTBUF1_A_P OUT1_i out1_x VDDP VDDP pch W=1.2u L=0.18u
Mn_OUTBUF1_A_N OUT1_i out1_x VSSP VSSP nch W=0.6u L=0.18u
R_OUTBUF1_A_GOUT OUT1_i OUT1_i_x 0.14
C_OUTBUF1_A_GOUT OUT1_i_x VSSP 1.0f
R_OUTBUF1_B_GIN OUT1_i OUT1_i_x 0.1
C_OUTBUF1_B_GIN OUT1_i_x VSSP 0.8f
Mp_OUTBUF1_B_P OUT1 OUT1_i_x VDDP VDDP pch W=1.2u L=0.18u
Mn_OUTBUF1_B_N OUT1 OUT1_i_x VSSP VSSP nch W=0.6u L=0.18u
R_OUTBUF1_B_GOUT OUT1 OUT1_x 0.14
C_OUTBUF1_B_GOUT OUT1_x VSSP 1.0f
R_OUT1_TR OUT1_i OUT1_x 0.13
C_OUT1_TR OUT1_x VSSP 0.8f
R_DFF0_L1_TG1_EN CLK1 CLK1_x 0.08
R_DFF0_L1_TG1_ENB CLKB CLKB_x 0.08
C_DFF0_L1_TG1_EN CLK1_x VSSP 0.6f
C_DFF0_L1_TG1_ENB CLKB_x VSSP 0.6f
Mp_DFF0_L1_TG1_P DFF0_L1_n1 CLKB_x d0 VDDP pch W=1.6u L=0.18u
Mn_DFF0_L1_TG1_N DFF0_L1_n1 CLK1_x d0 VSSP nch W=1.0u L=0.18u
R_DFF0_L1_TG1_IO d0 DFF0_L1_n1 0.05
C_DFF0_L1_TG1_IO DFF0_L1_n1 VSSP 0.5f
R_DFF0_L1_INV1_GIN DFF0_L1_n1 DFF0_L1_n1_x 0.1
C_DFF0_L1_INV1_GIN DFF0_L1_n1_x VSSP 0.8f
Mp_DFF0_L1_INV1_P DFF0_L1_n2 DFF0_L1_n1_x VDDP VDDP pch W=1.2u L=0.18u
Mn_DFF0_L1_INV1_N DFF0_L1_n2 DFF0_L1_n1_x VSSP VSSP nch W=0.6u L=0.18u
R_DFF0_L1_INV1_GOUT DFF0_L1_n2 DFF0_L1_n2_x 0.14
C_DFF0_L1_INV1_GOUT DFF0_L1_n2_x VSSP 1.0f
R_DFF0_L1_TG2_EN CLKB CLKB_x 0.08
R_DFF0_L1_TG2_ENB CLK1 CLK1_x 0.08
C_DFF0_L1_TG2_EN CLKB_x VSSP 0.6f
C_DFF0_L1_TG2_ENB CLK1_x VSSP 0.6f
Mp_DFF0_L1_TG2_P DFF0_L1_n3 CLK1_x DFF0_L1_n2 VDDP pch W=1.6u L=0.18u
Mn_DFF0_L1_TG2_N DFF0_L1_n3 CLKB_x DFF0_L1_n2 VSSP nch W=1.0u L=0.18u
R_DFF0_L1_TG2_IO DFF0_L1_n2 DFF0_L1_n3 0.05
C_DFF0_L1_TG2_IO DFF0_L1_n3 VSSP 0.5f
R_DFF0_L1_INV2_GIN DFF0_L1_n3 DFF0_L1_n3_x 0.1
C_DFF0_L1_INV2_GIN DFF0_L1_n3_x VSSP 0.8f
Mp_DFF0_L1_INV2_P DFF0_m DFF0_L1_n3_x VDDP VDDP pch W=1.2u L=0.18u
Mn_DFF0_L1_INV2_N DFF0_m DFF0_L1_n3_x VSSP VSSP nch W=0.6u L=0.18u
R_DFF0_L1_INV2_GOUT DFF0_m DFF0_m_x 0.14
C_DFF0_L1_INV2_GOUT DFF0_m_x VSSP 1.0f
R_DFF0_L1_INV3_GIN DFF0_m DFF0_m_x 0.1
C_DFF0_L1_INV3_GIN DFF0_m_x VSSP 0.8f
Mp_DFF0_L1_INV3_P DFF0_mb DFF0_m_x VDDP VDDP pch W=1.2u L=0.18u
Mn_DFF0_L1_INV3_N DFF0_mb DFF0_m_x VSSP VSSP nch W=0.6u L=0.18u
R_DFF0_L1_INV3_GOUT DFF0_mb DFF0_mb_x 0.14
C_DFF0_L1_INV3_GOUT DFF0_mb_x VSSP 1.0f
R_DFF0_L1_KEEP DFF0_m DFF0_L1_keep 10Meg
C_DFF0_L1_KEEP DFF0_L1_keep VSSP 0.2f
R_DFF0_L2_TG1_EN CLK1 CLK1_x 0.08
R_DFF0_L2_TG1_ENB CLKB CLKB_x 0.08
C_DFF0_L2_TG1_EN CLK1_x VSSP 0.6f
C_DFF0_L2_TG1_ENB CLKB_x VSSP 0.6f
Mp_DFF0_L2_TG1_P DFF0_L2_n1 CLKB_x DFF0_m VDDP pch W=1.6u L=0.18u
Mn_DFF0_L2_TG1_N DFF0_L2_n1 CLK1_x DFF0_m VSSP nch W=1.0u L=0.18u
R_DFF0_L2_TG1_IO DFF0_m DFF0_L2_n1 0.05
C_DFF0_L2_TG1_IO DFF0_L2_n1 VSSP 0.5f
R_DFF0_L2_INV1_GIN DFF0_L2_n1 DFF0_L2_n1_x 0.1
C_DFF0_L2_INV1_GIN DFF0_L2_n1_x VSSP 0.8f
Mp_DFF0_L2_INV1_P DFF0_L2_n2 DFF0_L2_n1_x VDDP VDDP pch W=1.2u L=0.18u
Mn_DFF0_L2_INV1_N DFF0_L2_n2 DFF0_L2_n1_x VSSP VSSP nch W=0.6u L=0.18u
R_DFF0_L2_INV1_GOUT DFF0_L2_n2 DFF0_L2_n2_x 0.14
C_DFF0_L2_INV1_GOUT DFF0_L2_n2_x VSSP 1.0f
R_DFF0_L2_TG2_EN CLKB CLKB_x 0.08
R_DFF0_L2_TG2_ENB CLK1 CLK1_x 0.08
C_DFF0_L2_TG2_EN CLKB_x VSSP 0.6f
C_DFF0_L2_TG2_ENB CLK1_x VSSP 0.6f
Mp_DFF0_L2_TG2_P DFF0_L2_n3 CLK1_x DFF0_L2_n2 VDDP pch W=1.6u L=0.18u
Mn_DFF0_L2_TG2_N DFF0_L2_n3 CLKB_x DFF0_L2_n2 VSSP nch W=1.0u L=0.18u
R_DFF0_L2_TG2_IO DFF0_L2_n2 DFF0_L2_n3 0.05
C_DFF0_L2_TG2_IO DFF0_L2_n3 VSSP 0.5f
R_DFF0_L2_INV2_GIN DFF0_L2_n3 DFF0_L2_n3_x 0.1
C_DFF0_L2_INV2_GIN DFF0_L2_n3_x VSSP 0.8f
Mp_DFF0_L2_INV2_P q0 DFF0_L2_n3_x VDDP VDDP pch W=1.2u L=0.18u
Mn_DFF0_L2_INV2_N q0 DFF0_L2_n3_x VSSP VSSP nch W=0.6u L=0.18u
R_DFF0_L2_INV2_GOUT q0 q0_x 0.14
C_DFF0_L2_INV2_GOUT q0_x VSSP 1.0f
R_DFF0_L2_INV3_GIN q0 q0_x 0.1
C_DFF0_L2_INV3_GIN q0_x VSSP 0.8f
Mp_DFF0_L2_INV3_P qb0 q0_x VDDP VDDP pch W=1.2u L=0.18u
Mn_DFF0_L2_INV3_N qb0 q0_x VSSP VSSP nch W=0.6u L=0.18u
R_DFF0_L2_INV3_GOUT qb0 qb0_x 0.14
C_DFF0_L2_INV3_GOUT qb0_x VSSP 1.0f
R_DFF0_L2_KEEP q0 DFF0_L2_keep 10Meg
C_DFF0_L2_KEEP DFF0_L2_keep VSSP 0.2f
R_DFF0_CLK CLK1 DFF0_clkx 0.09
C_DFF0_CLK DFF0_clkx VSSP 0.9f
R_NAND_D0_GA q0 q0_x 0.12
C_NAND_D0_GA q0_x VSSP 0.7f
R_NAND_D0_GB COMP COMP_x 0.12
C_NAND_D0_GB COMP_x VSSP 0.7f
Mp_NAND_D0_P1 d0 q0_x VDDP VDDP pch W=1.6u L=0.18u
Mp_NAND_D0_P2 d0 COMP_x VDDP VDDP pch W=1.6u L=0.18u
Mn_NAND_D0_N1 d0 q0_x NAND_D0_n1 VSSP nch W=1.0u L=0.18u
Mn_NAND_D0_N2 NAND_D0_n1 COMP_x VSSP VSSP nch W=1.0u L=0.18u
R_NAND_D0_GOUT d0 d0_x 0.16
C_NAND_D0_GOUT d0_x VSSP 1.0f
R_NAND_OUT0_GA nst nst_x 0.12
C_NAND_OUT0_GA nst_x VSSP 0.7f
R_NAND_OUT0_GB q0 q0_x 0.12
C_NAND_OUT0_GB q0_x VSSP 0.7f
Mp_NAND_OUT0_P1 out0 nst_x VDDP VDDP pch W=1.6u L=0.18u
Mp_NAND_OUT0_P2 out0 q0_x VDDP VDDP pch W=1.6u L=0.18u
Mn_NAND_OUT0_N1 out0 nst_x NAND_OUT0_n1 VSSP nch W=1.0u L=0.18u
Mn_NAND_OUT0_N2 NAND_OUT0_n1 q0_x VSSP VSSP nch W=1.0u L=0.18u
R_NAND_OUT0_GOUT out0 out0_x 0.16
C_NAND_OUT0_GOUT out0_x VSSP 1.0f
R_OUTBUF0_A_GIN out0 out0_x 0.1
C_OUTBUF0_A_GIN out0_x VSSP 0.8f
Mp_OUTBUF0_A_P OUT0_i out0_x VDDP VDDP pch W=1.2u L=0.18u
Mn_OUTBUF0_A_N OUT0_i out0_x VSSP VSSP nch W=0.6u L=0.18u
R_OUTBUF0_A_GOUT OUT0_i OUT0_i_x 0.14
C_OUTBUF0_A_GOUT OUT0_i_x VSSP 1.0f
R_OUTBUF0_B_GIN OUT0_i OUT0_i_x 0.1
C_OUTBUF0_B_GIN OUT0_i_x VSSP 0.8f
Mp_OUTBUF0_B_P OUT0 OUT0_i_x VDDP VDDP pch W=1.2u L=0.18u
Mn_OUTBUF0_B_N OUT0 OUT0_i_x VSSP VSSP nch W=0.6u L=0.18u
R_OUTBUF0_B_GOUT OUT0 OUT0_x 0.14
C_OUTBUF0_B_GOUT OUT0_x VSSP 1.0f
R_OUT0_TR OUT0_i OUT0_x 0.13
C_OUT0_TR OUT0_x VSSP 0.8f
R_DONE1_GIN q3 q3_x 0.1
C_DONE1_GIN q3_x VSSP 0.8f
Mp_DONE1_P done1 q3_x VDDP VDDP pch W=1.2u L=0.18u
Mn_DONE1_N done1 q3_x VSSP VSSP nch W=0.6u L=0.18u
R_DONE1_GOUT done1 done1_x 0.14
C_DONE1_GOUT done1_x VSSP 1.0f
R_DONE2_GIN q2 q2_x 0.1
C_DONE2_GIN q2_x VSSP 0.8f
Mp_DONE2_P done2 q2_x VDDP VDDP pch W=1.2u L=0.18u
Mn_DONE2_N done2 q2_x VSSP VSSP nch W=0.6u L=0.18u
R_DONE2_GOUT done2 done2_x 0.14
C_DONE2_GOUT done2_x VSSP 1.0f
R_DONE3_GIN q1 q1_x 0.1
C_DONE3_GIN q1_x VSSP 0.8f
Mp_DONE3_P done3 q1_x VDDP VDDP pch W=1.2u L=0.18u
Mn_DONE3_N done3 q1_x VSSP VSSP nch W=0.6u L=0.18u
R_DONE3_GOUT done3 done3_x 0.14
C_DONE3_GOUT done3_x VSSP 1.0f
R_DONE4_GIN q0 q0_x 0.1
C_DONE4_GIN q0_x VSSP 0.8f
Mp_DONE4_P done4 q0_x VDDP VDDP pch W=1.2u L=0.18u
Mn_DONE4_N done4 q0_x VSSP VSSP nch W=0.6u L=0.18u
R_DONE4_GOUT done4 done4_x 0.14
C_DONE4_GOUT done4_x VSSP 1.0f
R_DONE12_GA done1 done1_x 0.12
C_DONE12_GA done1_x VSSP 0.7f
R_DONE12_GB done2 done2_x 0.12
C_DONE12_GB done2_x VSSP 0.7f
Mp_DONE12_P1 done12 done1_x VDDP VDDP pch W=1.6u L=0.18u
Mp_DONE12_P2 done12 done2_x VDDP VDDP pch W=1.6u L=0.18u
Mn_DONE12_N1 done12 done1_x DONE12_n1 VSSP nch W=1.0u L=0.18u
Mn_DONE12_N2 DONE12_n1 done2_x VSSP VSSP nch W=1.0u L=0.18u
R_DONE12_GOUT done12 done12_x 0.16
C_DONE12_GOUT done12_x VSSP 1.0f
R_DONE34_GA done3 done3_x 0.12
C_DONE34_GA done3_x VSSP 0.7f
R_DONE34_GB done4 done4_x 0.12
C_DONE34_GB done4_x VSSP 0.7f
Mp_DONE34_P1 done34 done3_x VDDP VDDP pch W=1.6u L=0.18u
Mp_DONE34_P2 done34 done4_x VDDP VDDP pch W=1.6u L=0.18u
Mn_DONE34_N1 done34 done3_x DONE34_n1 VSSP nch W=1.0u L=0.18u
Mn_DONE34_N2 DONE34_n1 done4_x VSSP VSSP nch W=1.0u L=0.18u
R_DONE34_GOUT done34 done34_x 0.16
C_DONE34_GOUT done34_x VSSP 1.0f
R_DONEFIN_GA done12 done12_x 0.12
C_DONEFIN_GA done12_x VSSP 0.7f
R_DONEFIN_GB done34 done34_x 0.12
C_DONEFIN_GB done34_x VSSP 0.7f
Mp_DONEFIN_P1 DONE done12_x VDDP VDDP pch W=1.6u L=0.18u
Mp_DONEFIN_P2 DONE done34_x VDDP VDDP pch W=1.6u L=0.18u
Mn_DONEFIN_N1 DONE done12_x DONEFIN_n1 VSSP nch W=1.0u L=0.18u
Mn_DONEFIN_N2 DONEFIN_n1 done34_x VSSP VSSP nch W=1.0u L=0.18u
R_DONEFIN_GOUT DONE DONE_x 0.16
C_DONEFIN_GOUT DONE_x VSSP 1.0f

* top-level routing to logic outputs
R_DONE DONE DONE_P 0.10
C_DONE DONE_P VSSP 0.7f
R_OUT0 OUT0 OUT0_P 0.10
R_OUT1 OUT1 OUT1_P 0.10
R_OUT2 OUT2 OUT2_P 0.10
R_OUT3 OUT3 OUT3_P 0.10
C_OUT0 OUT0_P VSSP 0.7f
C_OUT1 OUT1_P VSSP 0.7f
C_OUT2 OUT2_P VSSP 0.7f
C_OUT3 OUT3_P VSSP 0.7f

.op
.tran 1n 100n
.measure tran vcomp_pp pp v(COMP) from=1u to=2u
.end
